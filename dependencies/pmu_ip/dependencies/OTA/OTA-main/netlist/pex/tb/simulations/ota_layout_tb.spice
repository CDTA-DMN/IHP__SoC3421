** sch_path: /foss/designs/ota/pex/tb/ota_layout_tb.sch
**.subckt ota_layout_tb
I0 net1 GND 20u
V1 VDD GND 3.3
V3 Vcm GND 1
Cl1 vout GND 100f
X999 vout net2 loopgainprobe
x1 VDD GND net1 Vcm net2 vout ota_layout
**** begin user architecture code

.lib cornerMOSlv.lib mos_tt
.lib cornerMOShv.lib mos_tt
.lib cornerHBT.lib hbt_typ
.lib cornerRES.lib res_typ
.lib cornerCAP.lib cap_typ

.include  /foss/designs/designs_/ITI_Analog/Misc/LoopGainProbe/stb.spi
*.include /foss/designs/ota/pex/output/ota_layout__ota_layout/magic_R/ota_layout.pex.spice
*.include /foss/designs/ota/pex/output/ota_layout__ota_layout/magic_CC/ota_layout.pex.spice
.include /foss/designs/ota/pex/output/ota_layout__ota_layout/magic_RC/ota_layout.pex.spice

**** end user architecture code
**.ends

* expanding   symbol:  /foss/designs/designs_/ITI_Analog/Misc/LoopGainProbe/loopgainprobe.sym # of pins=2
** sym_path: /foss/designs/designs_/ITI_Analog/Misc/LoopGainProbe/loopgainprobe.sym
** sch_path: /foss/designs/designs_/ITI_Analog/Misc/LoopGainProbe/loopgainprobe.sch
.subckt loopgainprobe a b
*.iopin a
*.iopin b
**** begin user architecture code

Ii 0 x DC 0 AC 0
Vi x a DC 0 AC 1
Vnodebuffer b x 0

**** end user architecture code
.ends

.GLOBAL GND
.GLOBAL VDD
.end
