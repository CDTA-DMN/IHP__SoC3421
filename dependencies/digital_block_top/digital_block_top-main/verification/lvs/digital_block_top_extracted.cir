* Extracted by KLayout with SG13G2 LVS runset on : 28/03/2026 23:07

.SUBCKT digital_block_top VSS VDD ADC_INPUT ADC_INPUT_VALID RESET FREEZE CLK
+ SCAN_VALID SCAN_OUT SCK MOSI MISO CS DATA_READY
X$459 VDD VSS sg13g2_decap_8
X$460 VDD VSS sg13g2_decap_8
X$461 VDD VSS sg13g2_decap_8
X$462 VDD VSS sg13g2_decap_8
X$465 VDD VSS sg13g2_decap_8
X$466 VDD VSS sg13g2_decap_8
X$467 VDD VSS sg13g2_decap_8
X$468 VDD VSS sg13g2_decap_8
X$469 VDD VSS sg13g2_decap_8
X$470 VDD VSS sg13g2_decap_8
X$471 VDD VSS sg13g2_decap_4
X$472 \$42 VDD VSS sg13g2_tiehi
X$473 VDD VSS sg13g2_decap_8
X$474 VDD VSS sg13g2_decap_8
X$475 VDD VSS sg13g2_decap_8
X$476 VDD VSS sg13g2_decap_8
X$477 VDD VSS sg13g2_decap_8
X$479 \$44 VDD VSS sg13g2_tiehi
X$480 VDD VSS sg13g2_decap_8
X$481 VDD VSS sg13g2_decap_8
X$482 VDD VSS sg13g2_decap_8
X$483 VDD VSS sg13g2_decap_8
X$484 VDD VSS sg13g2_decap_8
X$485 VDD VSS sg13g2_decap_8
X$486 VDD VSS sg13g2_decap_8
X$487 VDD VSS sg13g2_decap_8
X$488 VDD VSS sg13g2_decap_8
X$489 VDD VSS sg13g2_decap_8
X$492 VDD VSS sg13g2_decap_8
X$493 VDD VSS sg13g2_decap_8
X$496 \$48 VDD VSS sg13g2_tiehi
X$497 VDD VSS sg13g2_decap_8
X$498 VDD VSS sg13g2_decap_8
X$499 VDD VSS sg13g2_decap_8
X$500 VDD VSS sg13g2_decap_8
X$501 VDD VSS sg13g2_decap_8
X$502 VDD VSS sg13g2_decap_8
X$503 VDD VSS sg13g2_decap_4
X$505 \$18 VDD VSS sg13g2_tiehi
X$506 VDD VSS sg13g2_decap_8
X$507 VDD VSS sg13g2_decap_8
X$508 VDD VSS sg13g2_decap_8
X$509 VDD VSS sg13g2_decap_8
X$510 VDD VSS sg13g2_decap_8
X$511 VDD VSS sg13g2_decap_8
X$514 \$92 VDD VSS sg13g2_tiehi
X$515 VDD VSS sg13g2_decap_8
X$516 VDD VSS sg13g2_decap_8
X$517 VDD VSS sg13g2_decap_8
X$518 VDD VSS sg13g2_decap_8
X$519 VDD VSS sg13g2_decap_8
X$522 VDD VSS sg13g2_decap_4
X$524 \$91 VDD VSS sg13g2_tiehi
X$525 VDD VSS sg13g2_decap_8
X$526 VDD VSS sg13g2_decap_8
X$527 VDD VSS sg13g2_decap_8
X$530 VDD VSS \$20 \$52 \$19 sg13g2_nand2_1
X$531 \$88 VSS \$108 VDD \$20 \$21 sg13g2_a21oi_1
X$532 VDD VSS sg13g2_decap_8
X$533 VDD VSS sg13g2_decap_4
X$535 \$22 VDD VSS sg13g2_tiehi
X$536 VDD VSS sg13g2_decap_8
X$537 VDD VSS sg13g2_decap_8
X$538 VDD VSS sg13g2_decap_8
X$541 \$23 VDD VSS sg13g2_tiehi
X$542 VDD VSS sg13g2_decap_8
X$543 VDD VSS sg13g2_decap_8
X$544 VDD VSS sg13g2_decap_8
X$545 VDD VSS sg13g2_decap_4
X$547 \$24 VDD VSS sg13g2_tiehi
X$548 VSS \$24 \$38 \$25 \$65 VDD sg13g2_dfrbpq_1
X$549 VDD VSS sg13g2_decap_8
X$550 VDD VSS sg13g2_decap_8
X$553 VDD VSS sg13g2_decap_4
X$554 \$53 VDD VSS sg13g2_tiehi
X$555 VDD VSS sg13g2_decap_8
X$556 VDD VSS sg13g2_decap_8
X$557 VDD VSS sg13g2_decap_8
X$559 \$54 VDD VSS sg13g2_tiehi
X$560 VDD VSS sg13g2_decap_8
X$561 VDD VSS sg13g2_decap_8
X$562 VDD VSS sg13g2_decap_8
X$563 VDD VSS sg13g2_decap_8
X$564 VDD VSS sg13g2_decap_8
X$565 VDD VSS sg13g2_decap_8
X$567 \$26 VDD VSS sg13g2_tiehi
X$568 VDD VSS sg13g2_decap_8
X$569 VDD VSS sg13g2_decap_8
X$570 VDD VSS sg13g2_decap_8
X$571 VDD VSS sg13g2_decap_8
X$572 VDD VSS sg13g2_decap_4
X$573 \$27 VDD VSS sg13g2_tiehi
X$574 VDD VSS sg13g2_decap_8
X$575 VDD VSS sg13g2_decap_8
X$576 VDD VSS sg13g2_decap_8
X$577 VDD VSS sg13g2_decap_8
X$578 VDD VSS sg13g2_decap_4
X$579 VSS \$60 VDD ADC_INPUT sg13g2_buf_1
X$582 \$80 VDD VSS sg13g2_tiehi
X$583 VDD VSS sg13g2_decap_8
X$584 VDD VSS sg13g2_decap_8
X$585 VDD VSS sg13g2_decap_8
X$586 VDD VSS sg13g2_decap_8
X$587 VDD VSS sg13g2_decap_8
X$588 VDD VSS sg13g2_decap_8
X$590 VDD VSS sg13g2_decap_8
X$591 VDD VSS sg13g2_decap_8
X$592 VDD VSS sg13g2_decap_8
X$593 VDD VSS sg13g2_decap_8
X$597 VDD VSS sg13g2_decap_8
X$598 VDD VSS sg13g2_decap_8
X$599 VDD VSS sg13g2_decap_8
X$600 VDD VSS sg13g2_decap_8
X$601 VDD VSS sg13g2_decap_8
X$602 VDD VSS sg13g2_decap_8
X$604 VSS \$42 \$96 \$85 \$97 VDD sg13g2_dfrbpq_1
X$606 VSS VDD \$85 \$130 \$72 sg13g2_nor2b_1
X$607 \$43 VDD VSS sg13g2_tiehi
X$609 VDD VSS sg13g2_decap_4
X$611 VSS \$44 \$72 \$133 \$97 VDD sg13g2_dfrbpq_1
X$613 VDD VSS sg13g2_decap_4
X$615 VSS VDD \$133 \$130 \$74 sg13g2_nor2b_1
X$617 VDD VSS \$101 \$74 \$134 sg13g2_nand2_1
X$618 \$46 VSS \$176 VDD \$101 \$45 sg13g2_a21oi_1
X$619 VSS \$206 \$47 \$46 \$97 VDD sg13g2_dfrbpq_1
X$623 VDD VSS \$176 \$47 \$103 sg13g2_nand2_1
X$624 VDD VSS sg13g2_decap_8
X$625 VDD VSS sg13g2_decap_4
X$627 VSS \$48 \$49 \$139 \$140 VDD sg13g2_dfrbpq_1
X$629 VDD VSS sg13g2_decap_8
X$630 VDD VSS sg13g2_decap_4
X$632 VDD VSS \$75 \$49 \$134 sg13g2_nand2_1
X$633 \$50 VSS \$93 VDD \$75 \$21 sg13g2_a21oi_1
X$634 VSS \$18 \$143 \$50 \$142 VDD sg13g2_dfrbpq_1
X$638 VDD VSS \$93 \$143 \$103 sg13g2_nand2_1
X$639 VDD VSS sg13g2_decap_8
X$640 VDD VSS sg13g2_decap_8
X$641 VSS VDD \$51 \$21 \$49 sg13g2_nor2b_1
X$642 VSS \$92 \$147 \$51 \$142 VDD sg13g2_dfrbpq_1
X$644 VDD VSS sg13g2_decap_8
X$645 VDD VSS sg13g2_decap_8
X$649 VDD VSS sg13g2_decap_4
X$650 VSS \$91 \$261 \$149 \$106 VDD sg13g2_dfrbpq_1
X$652 VSS VDD \$149 \$21 \$52 sg13g2_nor2b_1
X$657 VDD VSS \$108 \$107 \$150 sg13g2_nand2_1
X$661 VSS \$250 \$265 \$52 \$107 VDD sg13g2_mux2_1
X$663 VSS \$22 \$107 \$88 \$106 VDD sg13g2_dfrbpq_1
X$667 VSS \$23 \$52 \$56 \$106 VDD sg13g2_dfrbpq_1
X$669 VDD VSS sg13g2_decap_8
X$670 VDD VSS sg13g2_decap_4
X$675 \$76 VDD VSS sg13g2_tiehi
X$677 VSS \$76 \$215 \$151 \$65 VDD sg13g2_dfrbpq_1
X$684 VDD VSS sg13g2_decap_8
X$689 VSS \$53 \$83 \$190 \$65 VDD sg13g2_dfrbpq_1
X$691 VSS \$54 \$182 \$154 \$115 VDD sg13g2_dfrbpq_1
X$695 VDD VSS \$182 \$152 \$79 sg13g2_nand2b_1
X$697 VDD VSS \$63 \$152 \$83 sg13g2_nand2_1
X$699 \$55 VSS \$79 VDD \$113 \$153 sg13g2_a21oi_1
X$701 VSS \$26 \$116 \$55 \$115 VDD sg13g2_dfrbpq_1
X$704 VDD VSS \$116 \$152 \$174 sg13g2_nand2b_1
X$705 \$121 VSS \$174 VDD \$63 \$156 sg13g2_a21oi_1
X$707 VSS \$27 \$227 \$121 \$159 VDD sg13g2_dfrbpq_1
X$709 VSS VDD \$56 \$156 \$60 sg13g2_nor2b_1
X$711 VDD VSS sg13g2_decap_8
X$717 VSS \$80 \$158 \$117 \$159 VDD sg13g2_dfrbpq_1
X$721 VDD VSS sg13g2_decap_8
X$722 VDD VSS sg13g2_decap_8
X$723 VDD VSS sg13g2_decap_8
X$725 VDD VSS sg13g2_decap_8
X$726 VDD VSS sg13g2_decap_8
X$727 VDD VSS sg13g2_decap_8
X$728 VDD VSS sg13g2_decap_8
X$731 VDD VSS sg13g2_decap_8
X$732 VDD VSS sg13g2_decap_8
X$734 \$198 VDD VSS sg13g2_tiehi
X$735 VDD VSS sg13g2_decap_8
X$736 VDD VSS sg13g2_decap_8
X$737 VDD VSS sg13g2_decap_8
X$738 \$166 VSS \$338 VDD \$234 \$130 sg13g2_a21oi_1
X$741 VDD VSS sg13g2_decap_4
X$743 VDD VSS \$234 \$96 \$134 sg13g2_nand2_1
X$744 VDD VSS sg13g2_decap_8
X$746 VDD VSS sg13g2_decap_8
X$748 VSS \$97 VDD sg13g2_buf_8
X$760 VSS \$97 \$720 VDD sg13g2_buf_16
X$768 VDD VSS sg13g2_decap_8
X$771 VDD VSS sg13g2_decap_8
X$778 VSS \$45 VDD \$130 sg13g2_buf_1
X$783 VDD VSS sg13g2_decap_4
X$790 \$206 VDD VSS sg13g2_tiehi
X$793 VDD VSS sg13g2_decap_8
X$796 VDD VSS \$136 \$74 \$207 sg13g2_nand2_1
X$799 \$782 VSS \$138 VDD \$136 \$432 sg13g2_a21oi_1
X$800 VDD VSS \$47 \$207 \$138 sg13g2_nand2b_1
X$803 VDD VSS sg13g2_decap_8
X$809 VDD VSS sg13g2_decap_8
X$810 VDD VSS sg13g2_decap_8
X$812 VDD VSS sg13g2_decap_8
X$816 VSS \$257 \$74 \$210 \$142 VDD sg13g2_dfrbpq_1
X$820 VDD VSS sg13g2_decap_8
X$828 VDD VSS sg13g2_decap_8
X$833 VDD VSS sg13g2_decap_8
X$838 \$334 VDD VSS sg13g2_tiehi
X$840 VDD VSS sg13g2_decap_8
X$841 VDD VSS sg13g2_decap_8
X$846 VDD VSS sg13g2_decap_4
X$848 VSS \$214 \$207 \$49 \$143 VDD sg13g2_mux2_1
X$850 VDD VSS sg13g2_decap_8
X$855 VDD VSS sg13g2_decap_8
X$859 \$145 VSS VDD \$250 \$297 \$214 \$262 sg13g2_a22oi_1
X$861 VSS VDD \$297 \$148 \$215 sg13g2_nor2b_1
X$862 VSS VDD \$262 \$215 \$148 sg13g2_nor2b_1
X$863 VDD VSS \$148 \$215 \$432 sg13g2_nand2b_1
X$865 VDD VSS sg13g2_decap_8
X$866 VDD VSS sg13g2_decap_8
X$869 VDD VSS sg13g2_decap_8
X$873 VDD VSS sg13g2_decap_8
X$874 VDD VSS sg13g2_decap_8
X$876 VDD VSS sg13g2_decap_8
X$878 VDD VSS sg13g2_decap_8
X$885 VDD VSS sg13g2_decap_8
X$892 VDD VSS sg13g2_decap_8
X$898 VDD VSS sg13g2_decap_8
X$902 VDD VSS sg13g2_decap_8
X$905 VDD VSS sg13g2_decap_8
X$906 VDD VSS sg13g2_decap_8
X$913 VDD VSS sg13g2_decap_8
X$917 VDD VSS sg13g2_decap_8
X$918 VDD VSS sg13g2_decap_8
X$921 VDD VSS sg13g2_decap_8
X$924 VDD VSS sg13g2_decap_8
X$925 VDD VSS sg13g2_decap_8
X$926 VDD VSS sg13g2_decap_8
X$930 VDD VSS sg13g2_decap_8
X$933 VDD VSS sg13g2_decap_8
X$935 VDD VSS sg13g2_decap_8
X$936 VDD VSS sg13g2_decap_8
X$940 VSS \$221 VDD \$190 \$354 \$358 \$517 \$270 sg13g2_a221oi_1
X$942 VDD VSS sg13g2_decap_8
X$944 VDD VSS sg13g2_decap_8
X$946 VDD VSS sg13g2_decap_8
X$947 VDD VSS sg13g2_decap_8
X$951 VDD VSS sg13g2_decap_8
X$953 VDD VSS sg13g2_decap_8
X$955 VDD VSS sg13g2_decap_8
X$956 VDD VSS sg13g2_decap_8
X$962 VDD VSS sg13g2_decap_8
X$971 VDD VSS \$113 \$152 \$223 sg13g2_nand2_1
X$975 VDD VSS sg13g2_decap_8
X$984 VDD VSS sg13g2_decap_8
X$985 VDD VSS sg13g2_decap_8
X$987 VDD VSS \$155 \$152 \$38 sg13g2_nand2_1
X$988 VDD VSS sg13g2_decap_8
X$992 VDD VSS sg13g2_decap_8
X$1002 VDD VSS sg13g2_decap_8
X$1006 VDD VSS sg13g2_decap_8
X$1007 VDD VSS sg13g2_decap_8
X$1009 VDD VSS sg13g2_decap_8
X$1012 \$117 VSS \$226 VDD \$362 \$156 sg13g2_a21oi_1
X$1018 VDD VSS \$227 \$229 \$226 sg13g2_nand2b_1
X$1025 \$272 VSS \$228 VDD \$155 \$156 sg13g2_a21oi_1
X$1027 VDD VSS sg13g2_decap_4
X$1028 VDD VSS \$158 \$229 \$228 sg13g2_nand2b_1
X$1030 VDD VSS sg13g2_decap_8
X$1031 VDD VSS sg13g2_decap_8
X$1033 VDD VSS sg13g2_decap_8
X$1034 VDD VSS sg13g2_decap_8
X$1035 VDD VSS sg13g2_decap_4
X$1037 VDD VSS sg13g2_decap_8
X$1038 VDD VSS sg13g2_decap_8
X$1039 VDD VSS sg13g2_decap_8
X$1040 VDD VSS sg13g2_decap_8
X$1044 VDD VSS sg13g2_decap_8
X$1045 VDD VSS sg13g2_decap_4
X$1047 VSS \$198 \$337 \$166 \$97 VDD sg13g2_dfrbpq_1
X$1051 VDD VSS \$338 \$337 \$103 sg13g2_nand2_1
X$1055 VDD VSS sg13g2_decap_8
X$1060 VDD VSS sg13g2_decap_8
X$1065 VDD VSS sg13g2_decap_8
X$1070 VSS VDD \$256 \$130 \$96 sg13g2_nor2b_1
X$1072 VSS \$43 \$339 \$256 \$97 VDD sg13g2_dfrbpq_1
X$1080 VSS VDD \$283 \$130 \$339 sg13g2_nor2b_1
X$1084 \$289 VDD VSS sg13g2_tiehi
X$1085 VSS \$289 \$341 \$283 \$140 VDD sg13g2_dfrbpq_1
X$1093 VDD VSS sg13g2_decap_8
X$1094 VDD VSS sg13g2_decap_8
X$1103 VDD VSS sg13g2_decap_8
X$1112 VDD VSS sg13g2_decap_8
X$1113 VDD VSS sg13g2_decap_4
X$1115 VSS VDD \$139 \$45 \$341 sg13g2_nor2b_1
X$1116 VDD VSS sg13g2_decap_8
X$1119 VSS VDD \$210 \$45 \$343 sg13g2_nor2b_1
X$1121 \$257 VDD VSS sg13g2_tiehi
X$1123 VDD VSS sg13g2_decap_8
X$1124 VDD VSS sg13g2_decap_8
X$1127 VDD VSS sg13g2_decap_4
X$1129 VSS \$21 VDD \$45 sg13g2_buf_1
X$1132 VDD VSS sg13g2_decap_8
X$1133 VDD VSS sg13g2_decap_8
X$1136 VSS \$334 \$343 \$301 \$142 VDD sg13g2_dfrbpq_1
X$1143 VDD VSS sg13g2_decap_8
X$1149 VSS VDD \$301 \$21 \$261 sg13g2_nor2b_1
X$1150 VDD VSS sg13g2_decap_8
X$1151 VDD VSS \$785 \$424 \$207 \$347 sg13g2_a21o_1
X$1157 \$347 VSS VDD \$262 \$147 \$297 \$261 sg13g2_a22oi_1
X$1169 VDD VSS \$389 \$147 \$134 sg13g2_nand2_1
X$1174 VSS \$134 VDD \$19 sg13g2_buf_1
X$1181 VDD VSS sg13g2_decap_8
X$1183 VDD VSS sg13g2_decap_8
X$1188 VSS \$103 VDD \$150 sg13g2_buf_1
X$1190 \$263 VSS \$501 VDD \$264 \$21 sg13g2_a21oi_1
X$1191 VDD VSS \$264 \$261 \$19 sg13g2_nand2_1
X$1192 VDD VSS sg13g2_decap_8
X$1193 VDD VSS sg13g2_decap_8
X$1194 VSS \$207 VDD \$265 sg13g2_buf_1
X$1195 VDD VSS sg13g2_decap_8
X$1196 VDD VSS sg13g2_decap_4
X$1197 \$266 VDD VSS sg13g2_tiehi
X$1198 VSS \$266 \$148 \$383 \$106 VDD sg13g2_dfrbpq_1
X$1202 VDD VSS sg13g2_decap_8
X$1203 VDD VSS sg13g2_decap_8
X$1204 VDD VSS sg13g2_decap_8
X$1205 VDD VSS sg13g2_decap_8
X$1206 VDD VSS sg13g2_decap_8
X$1207 VDD VSS sg13g2_decap_4
X$1209 VDD VSS \$285 \$353 \$270 sg13g2_nand2_1
X$1210 VDD VSS \$354 \$356 \$317 sg13g2_nand2b_1
X$1211 \$25 VSS VDD \$269 \$285 \$318 \$317 sg13g2_a22oi_1
X$1212 VDD VSS sg13g2_decap_8
X$1213 VDD VSS sg13g2_decap_4
X$1214 VSS \$593 VDD \$269 \$356 \$416 sg13g2_o21ai_1
X$1216 VDD VSS \$65 \$I36198 sg13g2_inv_4
X$1221 VSS \$65 \$765 VDD sg13g2_buf_16
X$1228 VDD VSS sg13g2_decap_8
X$1229 VDD VSS sg13g2_decap_8
X$1231 VDD VSS sg13g2_decap_8
X$1232 VDD VSS sg13g2_decap_8
X$1233 VDD VSS sg13g2_decap_8
X$1234 VDD VSS sg13g2_decap_8
X$1236 VDD VSS sg13g2_decap_4
X$1239 \$154 VSS \$276 VDD \$320 \$153 sg13g2_a21oi_1
X$1246 VDD VSS sg13g2_decap_8
X$1248 VDD VSS sg13g2_decap_8
X$1249 VDD VSS sg13g2_decap_8
X$1250 VDD VSS sg13g2_decap_8
X$1256 VDD VSS sg13g2_decap_8
X$1257 VSS \$156 VDD \$153 sg13g2_buf_1
X$1258 VDD VSS \$361 \$152 \$276 sg13g2_nand2b_1
X$1259 VDD VSS sg13g2_decap_4
X$1261 VDD VSS \$362 \$323 \$152 sg13g2_nand2_1
X$1262 VDD VSS sg13g2_decap_8
X$1263 VDD VSS sg13g2_decap_8
X$1265 VDD VSS sg13g2_decap_8
X$1277 \$324 VDD VSS sg13g2_tiehi
X$1283 VSS \$324 \$461 \$272 \$159 VDD sg13g2_dfrbpq_1
X$1298 VDD VSS sg13g2_decap_8
X$1299 VDD VSS sg13g2_decap_8
X$1300 VDD VSS sg13g2_decap_8
X$1525 VDD VSS sg13g2_decap_8
X$1526 VDD VSS sg13g2_decap_8
X$1527 VDD VSS sg13g2_decap_8
X$1528 VDD VSS sg13g2_decap_8
X$1530 VDD VSS sg13g2_decap_8
X$1531 VDD VSS sg13g2_decap_8
X$1532 VDD VSS sg13g2_decap_8
X$1533 VDD VSS sg13g2_decap_8
X$1534 VDD VSS sg13g2_decap_8
X$1535 VDD VSS sg13g2_decap_8
X$1537 VDD VSS \$337 \$431 \$433 sg13g2_nand2b_1
X$1539 \$610 VSS \$433 VDD \$478 \$432 sg13g2_a21oi_1
X$1542 VDD VSS \$478 \$96 \$431 sg13g2_nand2_1
X$1543 VDD VSS sg13g2_decap_8
X$1544 VDD VSS sg13g2_decap_8
X$1545 VDD VSS sg13g2_decap_8
X$1546 VDD VSS sg13g2_decap_4
X$1548 VDD VSS \$385 \$72 \$134 sg13g2_nand2_1
X$1549 VDD VSS sg13g2_decap_8
X$1550 VDD VSS sg13g2_decap_8
X$1552 VDD VSS \$484 \$72 \$431 sg13g2_nand2_1
X$1553 VDD VSS sg13g2_decap_8
X$1554 VDD VSS sg13g2_decap_8
X$1556 VDD VSS \$726 \$341 \$431 sg13g2_nand2_1
X$1559 VSS \$431 VDD \$207 sg13g2_buf_1
X$1560 VDD VSS sg13g2_decap_8
X$1561 VDD VSS sg13g2_decap_8
X$1562 VDD VSS sg13g2_decap_4
X$1565 VDD VSS \$386 \$341 \$134 sg13g2_nand2_1
X$1566 \$733 VSS \$387 VDD \$386 \$45 sg13g2_a21oi_1
X$1567 VDD VSS \$387 \$490 \$103 sg13g2_nand2_1
X$1568 VDD VSS sg13g2_decap_8
X$1569 VDD VSS sg13g2_decap_8
X$1570 VDD VSS sg13g2_decap_8
X$1571 VDD VSS sg13g2_decap_8
X$1572 VDD VSS sg13g2_decap_4
X$1573 VDD VSS \$492 \$343 \$207 sg13g2_nand2_1
X$1574 VDD VSS sg13g2_decap_4
X$1576 VDD VSS \$561 \$343 \$134 sg13g2_nand2_1
X$1577 \$417 VSS \$663 VDD \$561 \$45 sg13g2_a21oi_1
X$1578 VDD VSS sg13g2_decap_8
X$1579 VDD VSS sg13g2_decap_8
X$1580 VDD VSS sg13g2_decap_8
X$1581 VDD VSS sg13g2_decap_8
X$1582 VDD VSS sg13g2_decap_8
X$1583 VDD VSS sg13g2_decap_4
X$1584 VDD VSS \$142 \$I35506 sg13g2_inv_1
X$1585 VSS \$142 \$789 VDD sg13g2_buf_16
X$1588 VSS \$297 VDD \$424 \$499 \$207 \$570 \$262 sg13g2_a221oi_1
X$1589 VDD VSS sg13g2_decap_8
X$1590 VDD VSS sg13g2_decap_8
X$1591 VDD VSS sg13g2_decap_8
X$1593 \$500 VDD VSS sg13g2_tiehi
X$1594 VSS \$500 \$570 \$263 \$106 VDD sg13g2_dfrbpq_1
X$1595 VDD VSS sg13g2_decap_4
X$1597 VDD VSS \$265 \$444 \$445 \$19 sg13g2_and3_1
X$1598 VDD VSS sg13g2_decap_8
X$1599 VDD VSS sg13g2_decap_8
X$1602 VDD VSS \$394 \$445 sg13g2_inv_1
X$1603 VDD VSS sg13g2_decap_8
X$1604 VDD VSS sg13g2_decap_8
X$1605 VDD VSS sg13g2_decap_8
X$1606 VDD VSS sg13g2_decap_8
X$1608 VSS \$444 VDD ADC_INPUT_VALID sg13g2_buf_1
X$1609 VDD VSS sg13g2_decap_8
X$1610 \$503 VSS VDD \$269 \$506 \$318 \$448 sg13g2_a22oi_1
X$1611 VDD VSS \$420 \$451 \$318 sg13g2_nor2_1
X$1613 VDD VSS \$270 \$448 \$510 sg13g2_nand2b_1
X$1614 VSS \$510 VDD \$151 \$318 \$421 \$420 \$515 sg13g2_a221oi_1
X$1615 VDD VSS \$451 \$354 \$517 \$518 \$421 sg13g2_nor4_1
X$1617 VSS \$393 VDD \$453 \$506 \$354 sg13g2_o21ai_1
X$1619 VSS \$553 VDD \$593 \$393 \$420 sg13g2_o21ai_1
X$1621 VDD VSS \$634 \$453 \$358 sg13g2_nor2_1
X$1624 VSS \$221 VDD \$420 \$356 \$451 sg13g2_o21ai_1
X$1626 VDD VSS \$451 \$356 \$416 \$517 \$560 sg13g2_or4_1
X$1627 VDD VSS sg13g2_decap_8
X$1629 VSS \$410 VDD \$560 \$420 \$531 sg13g2_o21ai_1
X$1630 VDD VSS sg13g2_decap_8
X$1631 VDD VSS sg13g2_decap_8
X$1632 \$559 VDD VSS sg13g2_tiehi
X$1633 VSS \$559 \$394 \$410 \$115 VDD sg13g2_dfrbpq_1
X$1634 VDD VSS \$320 \$152 \$394 sg13g2_nand2_1
X$1635 VDD VSS sg13g2_decap_4
X$1637 \$545 VDD VSS sg13g2_tiehi
X$1638 VSS \$545 \$323 \$553 \$115 VDD sg13g2_dfrbpq_1
X$1639 VDD VSS sg13g2_decap_8
X$1642 VSS \$152 VDD \$909 sg13g2_buf_1
X$1643 \$395 VDD VSS sg13g2_tiehi
X$1644 VSS \$395 \$361 \$690 \$159 VDD sg13g2_dfrbpq_1
X$1646 VDD VSS sg13g2_decap_8
X$1649 VDD VSS \$461 \$229 \$397 sg13g2_nand2b_1
X$1650 VDD VSS sg13g2_decap_8
X$1651 VDD VSS sg13g2_decap_8
X$1652 VDD VSS sg13g2_decap_8
X$1653 VDD VSS sg13g2_decap_8
X$1654 VDD VSS sg13g2_decap_4
X$1898 VDD VSS sg13g2_decap_8
X$1899 VDD VSS sg13g2_decap_8
X$1900 VDD VSS sg13g2_decap_8
X$1901 VDD VSS sg13g2_decap_8
X$1902 VDD VSS sg13g2_decap_8
X$1903 VDD VSS sg13g2_decap_8
X$1904 VDD VSS sg13g2_decap_8
X$1905 VDD VSS sg13g2_decap_8
X$1906 VDD VSS sg13g2_decap_8
X$1908 VDD VSS \$700 \$668 \$103 sg13g2_nand2_1
X$1909 \$642 VSS \$700 VDD \$669 \$130 sg13g2_a21oi_1
X$1911 VDD VSS \$669 \$339 \$134 sg13g2_nand2_1
X$1913 VDD VSS \$671 \$339 \$431 sg13g2_nand2_1
X$1914 VDD VSS sg13g2_decap_8
X$1915 VDD VSS sg13g2_decap_8
X$1916 VDD VSS sg13g2_decap_8
X$1917 VDD VSS sg13g2_decap_8
X$1920 VDD VSS sg13g2_decap_4
X$1922 \$649 VSS \$716 VDD \$385 \$130 sg13g2_a21oi_1
X$1924 VDD VSS sg13g2_decap_4
X$1926 VDD VSS \$716 \$672 \$103 sg13g2_nand2_1
X$1928 VDD VSS \$672 \$431 \$722 sg13g2_nand2b_1
X$1930 \$482 VSS \$722 VDD \$484 \$432 sg13g2_a21oi_1
X$1933 VDD VSS sg13g2_decap_8
X$1934 VDD VSS sg13g2_decap_4
X$1936 \$674 VSS \$728 VDD \$726 \$432 sg13g2_a21oi_1
X$1939 VDD VSS sg13g2_decap_4
X$1941 VDD VSS \$490 \$431 \$728 sg13g2_nand2b_1
X$1944 VDD VSS sg13g2_decap_8
X$1947 \$614 VDD VSS sg13g2_tiehi
X$1948 VSS \$614 \$490 \$733 \$140 VDD sg13g2_dfrbpq_1
X$1951 VDD VSS sg13g2_decap_8
X$1952 VDD VSS sg13g2_decap_8
X$1953 VDD VSS sg13g2_decap_8
X$1954 \$1111 VSS \$493 VDD \$492 \$432 sg13g2_a21oi_1
X$1956 VDD VSS sg13g2_decap_4
X$1957 VDD VSS \$617 \$207 \$493 sg13g2_nand2b_1
X$1958 VDD VSS \$663 \$617 \$103 sg13g2_nand2_1
X$1960 VDD VSS sg13g2_decap_8
X$1961 VDD VSS sg13g2_decap_8
X$1964 VDD VSS sg13g2_decap_8
X$1965 VDD VSS sg13g2_decap_8
X$1966 VDD VSS sg13g2_decap_8
X$1968 VDD VSS sg13g2_decap_8
X$1969 VDD VSS sg13g2_decap_8
X$1971 \$661 VDD VSS sg13g2_tiehi
X$1972 VSS \$661 \$499 \$660 \$142 VDD sg13g2_dfrbpq_1
X$1974 VDD VSS sg13g2_decap_8
X$1975 VDD VSS sg13g2_decap_8
X$1976 VDD VSS sg13g2_decap_8
X$1977 VDD VSS \$501 \$570 \$150 sg13g2_nand2_1
X$1978 VDD VSS sg13g2_decap_8
X$1979 VDD VSS sg13g2_decap_8
X$1980 VDD VSS sg13g2_decap_8
X$1981 VDD VSS sg13g2_decap_8
X$1985 VSS VDD \$150 \$445 \$444 \$265 sg13g2_nand3_1
X$1986 VDD VSS sg13g2_decap_4
X$1987 VSS \$106 \$765 VDD sg13g2_buf_16
X$1990 VDD VSS sg13g2_decap_8
X$1991 VDD VSS sg13g2_decap_8
X$1992 VDD VSS sg13g2_decap_8
X$1993 VDD VSS sg13g2_decap_4
X$1995 VSS \$383 VDD \$503 \$651 \$648 sg13g2_o21ai_1
X$1996 VDD VSS \$604 \$353 \$448 sg13g2_nor2_1
X$1999 VSS VDD \$651 \$420 \$604 \$353 sg13g2_nand3_1
X$2000 VDD VSS sg13g2_decap_4
X$2004 VSS \$515 \$353 \$506 \$628 VDD sg13g2_mux2_1
X$2008 VSS \$628 \$453 \$604 VDD sg13g2_nor2_2
X$2010 VSS \$353 VDD \$416 sg13g2_buf_1
X$2013 VDD VSS \$751 \$518 \$628 sg13g2_nand2_1
X$2014 VDD VSS \$270 \$518 \$631 sg13g2_nand2_1
X$2018 \$634 VSS \$685 VDD \$416 \$517 sg13g2_a21oi_1
X$2020 VDD VSS sg13g2_decap_8
X$2021 VDD VSS \$354 \$416 sg13g2_inv_4
X$2023 VDD VSS \$451 \$416 \$531 sg13g2_nor2_1
X$2025 \$533 VSS \$737 VDD \$751 \$517 sg13g2_a21oi_1
X$2026 VDD VSS \$531 \$638 \$742 sg13g2_nand2b_1
X$2028 VDD VSS sg13g2_decap_8
X$2029 VDD VSS sg13g2_decap_8
X$2032 \$534 VDD VSS sg13g2_tiehi
X$2033 VSS \$534 \$223 \$533 \$115 VDD sg13g2_dfrbpq_1
X$2037 VDD VSS sg13g2_decap_8
X$2038 VDD VSS sg13g2_decap_8
X$2040 VDD VSS sg13g2_decap_8
X$2041 VDD VSS sg13g2_decap_8
X$2042 VDD VSS sg13g2_decap_8
X$2043 VDD VSS sg13g2_decap_8
X$2044 VDD VSS sg13g2_decap_8
X$2045 VDD VSS sg13g2_decap_8
X$2046 VDD VSS sg13g2_decap_8
X$2047 VDD VSS sg13g2_decap_8
X$2048 VDD VSS sg13g2_decap_8
X$2049 VSS \$159 \$688 VDD sg13g2_buf_16
X$2050 VDD VSS sg13g2_decap_8
X$2051 VDD VSS sg13g2_decap_8
X$2052 VDD VSS sg13g2_decap_8
X$2053 VDD VSS sg13g2_decap_4
X$2309 VDD VSS sg13g2_decap_8
X$2310 VDD VSS sg13g2_decap_8
X$2311 VDD VSS sg13g2_decap_8
X$2312 VDD VSS sg13g2_decap_8
X$2317 VDD VSS sg13g2_decap_8
X$2318 VDD VSS sg13g2_decap_4
X$2320 VSS \$667 \$668 \$642 \$917 VDD sg13g2_dfrbpq_1
X$2322 VDD VSS \$668 \$431 \$818 sg13g2_nand2b_1
X$2323 \$779 VSS \$818 VDD \$671 \$432 sg13g2_a21oi_1
X$2326 VDD VSS sg13g2_decap_8
X$2327 VDD VSS sg13g2_decap_8
X$2328 VDD VSS sg13g2_decap_8
X$2329 \$780 VDD VSS sg13g2_tiehi
X$2330 VSS \$780 \$672 \$649 \$140 VDD sg13g2_dfrbpq_1
X$2331 VDD VSS sg13g2_decap_8
X$2333 VDD VSS sg13g2_decap_8
X$2334 VDD VSS sg13g2_decap_8
X$2335 VDD VSS sg13g2_decap_8
X$2336 VDD VSS sg13g2_decap_8
X$2337 VDD VSS sg13g2_decap_8
X$2338 VDD VSS sg13g2_decap_8
X$2339 \$931 VDD VSS sg13g2_tiehi
X$2344 VDD VSS sg13g2_decap_4
X$2345 VSS \$140 \$789 VDD sg13g2_buf_16
X$2346 VDD VSS sg13g2_decap_8
X$2347 VDD VSS sg13g2_decap_4
X$2349 \$839 VDD VSS sg13g2_tiehi
X$2350 VSS \$839 \$617 \$417 \$140 VDD sg13g2_dfrbpq_1
X$2351 VDD VSS sg13g2_decap_8
X$2352 \$845 VDD VSS sg13g2_tiehi
X$2353 VSS \$845 \$784 \$783 \$142 VDD sg13g2_dfrbpq_1
X$2354 VDD VSS sg13g2_decap_8
X$2355 VDD VSS sg13g2_decap_8
X$2356 VDD VSS sg13g2_decap_8
X$2357 VDD VSS sg13g2_decap_4
X$2359 \$660 VSS \$677 VDD \$389 \$21 sg13g2_a21oi_1
X$2360 VDD VSS \$677 \$499 \$103 sg13g2_nand2_1
X$2361 VDD VSS sg13g2_decap_8
X$2362 VDD VSS sg13g2_decap_8
X$2367 VDD VSS sg13g2_decap_8
X$2368 VDD VSS sg13g2_decap_8
X$2369 VDD VSS sg13g2_decap_8
X$2370 VDD VSS sg13g2_decap_8
X$2372 \$790 VDD VSS sg13g2_tiehi
X$2374 VSS \$790 \$265 \$865 \$106 VDD sg13g2_dfrbpq_1
X$2375 VDD VSS sg13g2_decap_8
X$2376 VDD VSS sg13g2_decap_8
X$2377 VDD VSS sg13g2_decap_8
X$2378 VDD VSS sg13g2_decap_8
X$2379 VDD VSS sg13g2_decap_8
X$2380 VDD VSS sg13g2_decap_4
X$2382 VDD VSS \$604 \$876 \$679 \$353 sg13g2_nor3_1
X$2383 VDD VSS \$506 \$679 \$604 sg13g2_and2_1
X$2385 VSS \$772 VDD \$269 \$506 \$876 sg13g2_o21ai_1
X$2387 VSS VDD \$906 \$772 \$881 \$742 sg13g2_nand3_1
X$2389 VDD VSS \$648 \$679 \$453 sg13g2_xnor2_1
X$2391 VSS \$269 \$453 \$517 VDD sg13g2_nor2_2
X$2393 VSS \$604 VDD \$631 sg13g2_buf_1
X$2395 VDD VSS \$356 \$631 \$518 sg13g2_nand2b_2
X$2400 VDD VSS sg13g2_decap_8
X$2401 VDD VSS sg13g2_decap_4
X$2402 VDD VSS \$737 \$804 \$354 \$518 sg13g2_nand3b_1
X$2403 VDD VSS sg13g2_decap_8
X$2406 \$638 VSS \$685 VDD \$518 \$517 sg13g2_a21oi_1
X$2407 VDD VSS sg13g2_decap_8
X$2408 VDD VSS sg13g2_decap_8
X$2409 VDD VSS sg13g2_decap_8
X$2410 VDD VSS sg13g2_decap_4
X$2411 VDD VSS \$115 \$I35495 sg13g2_inv_1
X$2412 VSS \$115 \$688 VDD sg13g2_buf_16
X$2413 \$810 VDD VSS sg13g2_tiehi
X$2414 VDD VSS sg13g2_decap_8
X$2415 VDD VSS sg13g2_decap_8
X$2416 VDD VSS sg13g2_decap_8
X$2417 VDD VSS sg13g2_decap_8
X$2418 VDD VSS sg13g2_decap_8
X$2420 \$690 VSS \$704 VDD \$837 \$153 sg13g2_a21oi_1
X$2421 \$811 VDD VSS sg13g2_tiehi
X$2422 VDD VSS sg13g2_decap_4
X$2423 \$832 VSS \$812 VDD \$691 \$156 sg13g2_a21oi_1
X$2424 VDD VSS sg13g2_decap_8
X$2425 VDD VSS \$813 \$229 \$704 sg13g2_nand2b_1
X$2430 VDD VSS sg13g2_decap_8
X$2431 VDD VSS \$695 \$229 \$812 sg13g2_nand2b_1
X$2432 \$816 VDD VSS sg13g2_tiehi
X$2433 VSS \$816 \$695 \$912 \$159 VDD sg13g2_dfrbpq_1
X$2436 VDD VSS sg13g2_decap_8
X$2437 VDD VSS sg13g2_decap_8
X$2438 VDD VSS sg13g2_decap_8
X$2439 VDD VSS sg13g2_decap_8
X$2440 VDD VSS sg13g2_decap_8
X$2441 VDD VSS sg13g2_decap_8
X$2444 \$667 VDD VSS sg13g2_tiehi
X$2446 VDD VSS sg13g2_decap_4
X$2448 VSS \$917 \$720 VDD sg13g2_buf_16
X$2458 VDD VSS sg13g2_decap_8
X$2461 VDD VSS sg13g2_decap_8
X$2462 VDD VSS sg13g2_decap_8
X$2463 VDD VSS sg13g2_decap_8
X$2468 VDD VSS sg13g2_decap_8
X$2471 VDD VSS sg13g2_decap_8
X$2473 VDD VSS sg13g2_decap_8
X$2474 VDD VSS sg13g2_decap_8
X$2478 VDD VSS sg13g2_decap_8
X$2479 VDD VSS sg13g2_decap_8
X$2480 VDD VSS sg13g2_decap_8
X$2481 VDD VSS sg13g2_decap_8
X$2482 VDD VSS sg13g2_decap_8
X$2483 VDD VSS \$830 \$782 \$895 sg13g2_nand2_1
X$2484 VSS \$930 VDD \$830 \$896 \$895 sg13g2_o21ai_1
X$2485 VSS \$931 \$836 \$930 \$140 VDD sg13g2_dfrbpq_1
X$2489 VDD VSS sg13g2_decap_8
X$2492 VDD VSS sg13g2_decap_8
X$2493 VDD VSS sg13g2_decap_8
X$2495 VDD VSS sg13g2_decap_8
X$2499 VDD VSS sg13g2_decap_8
X$2502 VDD VSS sg13g2_decap_8
X$2504 VDD VSS sg13g2_decap_8
X$2505 VDD VSS sg13g2_decap_8
X$2507 VDD VSS sg13g2_decap_8
X$2511 VSS \$783 VDD \$937 \$785 \$898 sg13g2_o21ai_1
X$2513 VDD VSS sg13g2_decap_4
X$2517 VSS VDD \$937 \$898 \$900 \$784 sg13g2_nand3_1
X$2519 VDD VSS sg13g2_decap_8
X$2520 VDD VSS sg13g2_decap_8
X$2522 VDD VSS sg13g2_decap_8
X$2523 VDD VSS \$786 \$785 \$946 sg13g2_nand2b_1
X$2524 VSS \$858 VDD \$946 \$788 \$786 sg13g2_o21ai_1
X$2525 VDD VSS \$788 \$902 \$900 sg13g2_nand2_1
X$2527 \$952 VDD VSS sg13g2_tiehi
X$2529 VSS \$952 \$902 \$858 \$142 VDD sg13g2_dfrbpq_1
X$2536 VDD VSS sg13g2_decap_8
X$2537 VDD VSS sg13g2_decap_8
X$2538 VDD VSS sg13g2_decap_8
X$2539 VDD VSS sg13g2_decap_8
X$2541 VDD VSS sg13g2_decap_8
X$2546 VSS VDD \$865 \$445 \$792 \$1347 sg13g2_nand3_1
X$2548 VDD VSS sg13g2_decap_8
X$2551 VDD VSS \$792 \$265 \$444 sg13g2_nand2b_2
X$2554 \$904 VDD VSS sg13g2_tiehi
X$2556 VSS VDD \$863 \$444 \$265 sg13g2_nor2b_1
X$2558 VDD VSS sg13g2_decap_8
X$2560 VDD VSS sg13g2_decap_8
X$2561 VDD VSS sg13g2_decap_8
X$2563 VDD VSS sg13g2_decap_8
X$2564 VDD VSS sg13g2_decap_8
X$2574 VDD VSS sg13g2_decap_4
X$2580 VDD VSS \$451 \$354 \$420 \$356 \$879 sg13g2_nor4_1
X$2587 VSS VDD \$881 \$420 \$888 \$353 sg13g2_nand3_1
X$2595 VSS \$888 VDD \$685 \$679 \$451 sg13g2_o21ai_1
X$2596 VSS \$518 VDD \$679 sg13g2_buf_1
X$2603 VDD VSS sg13g2_decap_8
X$2609 VDD VSS sg13g2_decap_8
X$2612 VDD VSS sg13g2_decap_8
X$2620 VDD VSS \$631 \$685 sg13g2_inv_1
X$2622 VDD VSS sg13g2_decap_8
X$2624 VDD VSS sg13g2_decap_8
X$2630 VDD VSS sg13g2_decap_8
X$2636 VDD VSS sg13g2_decap_8
X$2640 VDD VSS sg13g2_decap_8
X$2645 VDD VSS sg13g2_decap_8
X$2646 VDD VSS sg13g2_decap_8
X$2647 VDD VSS sg13g2_decap_8
X$2648 VSS \$420 VDD \$908 sg13g2_buf_1
X$2654 VDD VSS \$908 \$517 sg13g2_inv_1
X$2656 VDD VSS sg13g2_decap_8
X$2658 VDD VSS sg13g2_decap_8
X$2662 VDD VSS sg13g2_decap_8
X$2665 VDD VSS sg13g2_decap_8
X$2667 VDD VSS sg13g2_decap_8
X$2669 VDD VSS sg13g2_decap_8
X$2670 VDD VSS sg13g2_decap_8
X$2671 VDD VSS sg13g2_decap_8
X$2672 VDD VSS sg13g2_decap_4
X$2673 VDD VSS \$837 \$910 \$909 sg13g2_nand2_1
X$2679 VSS \$811 \$813 \$832 \$159 VDD sg13g2_dfrbpq_1
X$2691 VDD VSS sg13g2_decap_8
X$2694 VDD VSS sg13g2_decap_8
X$2701 VDD VSS sg13g2_decap_8
X$2707 VDD VSS sg13g2_decap_8
X$2709 VDD VSS sg13g2_decap_8
X$2710 VDD VSS sg13g2_decap_8
X$2714 VDD VSS sg13g2_decap_8
X$2715 VDD VSS sg13g2_decap_8
X$2716 VDD VSS sg13g2_decap_4
X$2718 VSS \$1007 \$1044 \$1038 \$917 VDD sg13g2_dfrbpq_1
X$2721 VDD VSS sg13g2_decap_4
X$2723 \$1043 VDD VSS sg13g2_tiehi
X$2724 VDD VSS \$917 \$I36196 sg13g2_inv_4
X$2728 VSS \$1043 \$1070 \$1009 \$917 VDD sg13g2_dfrbpq_1
X$2734 VDD VSS sg13g2_decap_8
X$2735 VDD VSS sg13g2_decap_4
X$2737 VSS \$967 \$968 \$892 \$1011 VDD sg13g2_dfrbpq_1
X$2743 VDD VSS \$892 \$1014 \$891 sg13g2_nand2_1
X$2744 VDD VSS sg13g2_decap_4
X$2746 \$893 VDD VSS sg13g2_tiehi
X$2747 VSS \$893 \$971 \$969 \$140 VDD sg13g2_dfrbpq_1
X$2756 VDD VSS \$896 \$836 \$1016 sg13g2_nand2_1
X$2761 VDD VSS sg13g2_decap_8
X$2767 VDD VSS sg13g2_decap_8
X$2771 VDD VSS sg13g2_decap_8
X$2775 VDD VSS sg13g2_decap_8
X$2776 VDD VSS sg13g2_decap_4
X$2780 VSS \$895 VDD \$786 sg13g2_buf_1
X$2781 \$1020 VDD VSS sg13g2_tiehi
X$2782 VDD VSS sg13g2_decap_8
X$2783 VDD VSS sg13g2_decap_8
X$2784 VDD VSS sg13g2_decap_8
X$2785 VDD VSS sg13g2_decap_4
X$2786 VSS \$1067 \$973 \$999 \$1076 VDD sg13g2_dfrbpq_1
X$2792 VDD VSS sg13g2_decap_8
X$2800 VDD VSS sg13g2_decap_8
X$2806 VDD VSS sg13g2_decap_8
X$2810 VDD VSS sg13g2_decap_8
X$2812 VDD VSS sg13g2_decap_8
X$2814 VDD VSS sg13g2_decap_8
X$2824 VDD VSS sg13g2_decap_8
X$2838 VDD VSS sg13g2_decap_4
X$2842 \$1085 VDD VSS sg13g2_tiehi
X$2847 VDD VSS sg13g2_decap_8
X$2850 VDD VSS sg13g2_decap_8
X$2854 VDD VSS sg13g2_decap_8
X$2855 VDD VSS sg13g2_decap_8
X$2858 VDD VSS sg13g2_decap_8
X$2859 VDD VSS sg13g2_decap_8
X$2860 VDD VSS sg13g2_decap_8
X$2861 VDD VSS sg13g2_decap_8
X$2862 VDD VSS sg13g2_decap_8
X$2868 VDD VSS sg13g2_decap_8
X$2870 VDD VSS sg13g2_decap_8
X$2878 VSS \$904 \$1027 \$879 \$106 VDD sg13g2_dfrbpq_1
X$2890 VSS \$1028 \$975 \$353 \$1004 VDD sg13g2_dfrbpq_1
X$2893 VSS \$1004 \$765 VDD sg13g2_buf_16
X$2915 VDD VSS sg13g2_decap_8
X$2917 VDD VSS sg13g2_decap_8
X$2920 VDD VSS sg13g2_decap_8
X$2925 VDD VSS sg13g2_decap_8
X$2926 VDD VSS \$804 \$631 \$451 sg13g2_xnor2_1
X$2927 VSS \$979 \$1214 \$518 \$115 VDD sg13g2_dfrbpq_1
X$2930 VDD VSS sg13g2_decap_8
X$2932 VDD VSS sg13g2_decap_8
X$2935 VDD VSS sg13g2_decap_8
X$2938 VDD VSS sg13g2_decap_8
X$2941 VDD VSS sg13g2_decap_4
X$2947 VSS \$810 \$1030 \$517 \$159 VDD sg13g2_dfrbpq_1
X$2949 VDD VSS sg13g2_decap_8
X$2950 VDD VSS sg13g2_decap_8
X$2951 VDD VSS sg13g2_decap_8
X$2953 VDD VSS sg13g2_decap_8
X$2960 VDD VSS sg13g2_decap_4
X$2963 VDD VSS \$691 \$1309 \$909 sg13g2_nand2_1
X$2966 VDD VSS sg13g2_decap_8
X$2968 VDD VSS sg13g2_decap_8
X$2971 VDD VSS sg13g2_decap_8
X$2973 VDD VSS sg13g2_decap_4
X$2974 \$912 VSS \$983 VDD \$1041 \$153 sg13g2_a21oi_1
X$2976 VDD VSS \$1034 \$229 \$983 sg13g2_nand2b_1
X$2977 VDD VSS sg13g2_decap_8
X$2978 VDD VSS sg13g2_decap_8
X$2979 VDD VSS sg13g2_decap_8
X$2981 VDD VSS sg13g2_decap_8
X$2982 VDD VSS sg13g2_decap_8
X$2983 VDD VSS sg13g2_decap_8
X$2986 \$1007 VDD VSS sg13g2_tiehi
X$2992 VDD VSS \$1038 \$1008 \$1127 sg13g2_nand2_1
X$2993 VDD VSS \$1008 \$1095 \$674 sg13g2_nand2_1
X$2996 VDD VSS sg13g2_decap_8
X$2997 VDD VSS sg13g2_decap_8
X$2999 VDD VSS sg13g2_decap_4
X$3003 VSS VDD \$1127 \$1096 \$1193 \$1044 sg13g2_nand3_1
X$3009 VDD VSS \$1009 \$1010 \$1133 sg13g2_nand2_1
X$3011 VDD VSS \$1010 \$1099 \$674 sg13g2_nand2_1
X$3014 VSS VDD \$1133 \$1193 \$1012 \$1070 sg13g2_nand3_1
X$3015 VDD VSS sg13g2_decap_8
X$3017 VDD VSS sg13g2_decap_8
X$3018 VDD VSS sg13g2_decap_8
X$3020 VDD VSS sg13g2_decap_8
X$3024 \$967 VDD VSS sg13g2_tiehi
X$3027 VDD VSS sg13g2_decap_8
X$3028 VDD VSS sg13g2_decap_8
X$3031 VDD VSS sg13g2_decap_4
X$3032 VDD VSS \$1014 \$1095 \$782 sg13g2_nand2_1
X$3034 VSS VDD \$891 \$1096 \$1016 \$968 sg13g2_nand3_1
X$3040 VDD VSS \$1106 \$782 \$1099 sg13g2_nand2_1
X$3041 VDD VSS \$969 \$1106 \$1015 sg13g2_nand2_1
X$3044 VDD VSS sg13g2_decap_4
X$3046 VSS VDD \$1015 \$1016 \$1012 \$971 sg13g2_nand3_1
X$3047 VDD VSS sg13g2_decap_8
X$3051 VDD VSS sg13g2_decap_8
X$3052 VDD VSS sg13g2_decap_8
X$3056 VDD VSS sg13g2_decap_8
X$3059 VDD VSS sg13g2_decap_8
X$3063 VDD VSS sg13g2_decap_8
X$3065 VDD VSS \$1091 \$1111 \$895 sg13g2_nand2_1
X$3067 VDD VSS \$1113 \$1064 \$1016 sg13g2_nand2_1
X$3068 VSS \$1018 VDD \$1091 \$1113 \$895 sg13g2_o21ai_1
X$3070 VSS \$1020 \$1064 \$1018 \$140 VDD sg13g2_dfrbpq_1
X$3075 VDD VSS sg13g2_decap_8
X$3078 \$1067 VDD VSS sg13g2_tiehi
X$3080 VDD VSS sg13g2_decap_8
X$3081 VDD VSS sg13g2_decap_4
X$3084 VSS \$999 VDD \$1114 \$1023 \$785 sg13g2_o21ai_1
X$3087 VSS VDD \$1114 \$900 \$1023 \$973 sg13g2_nand3_1
X$3089 VDD VSS sg13g2_decap_8
X$3090 VDD VSS sg13g2_decap_4
X$3092 VSS \$1110 \$1118 \$1056 \$784 \$973 \$1026 \$902 VDD sg13g2_mux4_1
X$3094 VSS VDD \$1155 \$900 \$1075 \$1026 sg13g2_nand3_1
X$3096 VSS \$1063 VDD \$1155 \$1075 \$785 sg13g2_o21ai_1
X$3097 VDD VSS sg13g2_decap_4
X$3100 VSS \$1085 \$1026 \$1063 \$1076 VDD sg13g2_dfrbpq_1
X$3105 VDD VSS sg13g2_decap_8
X$3107 \$1058 VDD VSS sg13g2_tiehi
X$3108 VSS \$1058 \$1301 \$1169 \$106 VDD sg13g2_dfrbpq_1
X$3109 VDD VSS sg13g2_decap_8
X$3110 VDD VSS sg13g2_decap_8
X$3111 VDD VSS sg13g2_decap_8
X$3114 VDD VSS sg13g2_decap_8
X$3116 VDD VSS sg13g2_decap_8
X$3119 VDD VSS sg13g2_decap_8
X$3120 VDD VSS sg13g2_decap_4
X$3124 \$1028 VDD VSS sg13g2_tiehi
X$3126 VDD VSS sg13g2_decap_8
X$3129 VDD VSS sg13g2_decap_8
X$3133 \$1077 VDD VSS sg13g2_tiehi
X$3135 VSS \$1077 \$1213 \$906 \$1004 VDD sg13g2_dfrbpq_1
X$3141 VDD VSS sg13g2_decap_4
X$3143 VSS \$1079 \$453 VDD sg13g2_inv_8
X$3147 VSS \$451 VDD \$1079 sg13g2_buf_1
X$3150 \$1120 VDD VSS sg13g2_tiehi
X$3152 VDD VSS sg13g2_decap_8
X$3155 VDD VSS sg13g2_decap_8
X$3163 \$979 VDD VSS sg13g2_tiehi
X$3165 VDD VSS sg13g2_decap_4
X$3166 VSS \$1264 \$1081 \$685 \$115 VDD sg13g2_dfrbpq_1
X$3171 VDD VSS sg13g2_decap_8
X$3172 VDD VSS sg13g2_decap_8
X$3176 VSS VDD \$1122 \$1081 \$1080 sg13g2_nor2b_1
X$3177 VDD VSS sg13g2_decap_8
X$3180 VDD VSS sg13g2_decap_8
X$3181 VDD VSS sg13g2_decap_8
X$3184 VDD VSS sg13g2_decap_4
X$3186 VSS \$910 VDD \$1030 sg13g2_buf_1
X$3188 VDD VSS sg13g2_decap_8
X$3189 VDD VSS sg13g2_decap_8
X$3190 VSS VDD \$1123 \$1080 \$1309 sg13g2_nor2b_1
X$3191 VDD VSS sg13g2_decap_8
X$3193 VDD VSS sg13g2_decap_8
X$3196 VDD VSS sg13g2_decap_8
X$3200 VDD VSS sg13g2_decap_4
X$3206 VDD VSS \$1041 \$1320 \$909 sg13g2_nand2_1
X$3208 VDD VSS sg13g2_decap_8
X$3211 \$1040 VDD VSS sg13g2_tiehi
X$3215 VSS \$1040 \$1034 \$1185 \$159 VDD sg13g2_dfrbpq_1
X$3223 VDD VSS sg13g2_decap_4
X$3436 VDD VSS sg13g2_decap_8
X$3437 VDD VSS sg13g2_decap_8
X$3438 VDD VSS sg13g2_decap_8
X$3439 VDD VSS sg13g2_decap_8
X$3445 VDD VSS sg13g2_decap_8
X$3447 VSS \$1279 \$1194 \$1229 \$917 VDD sg13g2_dfrbpq_1
X$3449 VDD VSS sg13g2_decap_8
X$3453 VSS \$1110 \$1188 \$1056 \$1044 \$1196 \$1070 \$1194 VDD sg13g2_mux4_1
X$3455 VDD VSS sg13g2_decap_8
X$3456 VDD VSS sg13g2_decap_8
X$3457 VDD VSS sg13g2_decap_8
X$3458 VDD VSS sg13g2_decap_4
X$3459 VDD VSS \$1396 \$1164 \$1241 sg13g2_nand2_1
X$3460 VDD VSS \$1164 \$782 \$1588 sg13g2_nand2_1
X$3461 VDD VSS sg13g2_decap_4
X$3463 VSS VDD \$1241 \$1016 \$1197 \$1198 sg13g2_nand3_1
X$3465 VDD VSS sg13g2_decap_8
X$3466 VDD VSS sg13g2_decap_8
X$3467 VDD VSS sg13g2_decap_8
X$3471 VSS \$1110 \$1254 \$1056 \$968 \$1198 \$971 \$836 VDD sg13g2_mux4_1
X$3473 VDD VSS sg13g2_decap_8
X$3479 VDD VSS sg13g2_decap_8
X$3480 VDD VSS sg13g2_decap_8
X$3481 VDD VSS sg13g2_decap_8
X$3482 VDD VSS sg13g2_decap_8
X$3484 \$1203 VDD VSS sg13g2_tiehi
X$3485 VDD VSS sg13g2_decap_8
X$3486 VDD VSS sg13g2_decap_8
X$3487 VDD VSS sg13g2_decap_8
X$3488 VDD VSS sg13g2_decap_8
X$3489 VDD VSS sg13g2_decap_8
X$3490 VDD VSS sg13g2_decap_4
X$3492 VSS \$1012 VDD \$1075 sg13g2_buf_1
X$3493 VSS \$1096 VDD \$898 sg13g2_buf_1
X$3494 VDD VSS sg13g2_decap_4
X$3496 \$1208 \$1075 \$1167 VDD VSS sg13g2_or2_1
X$3497 VSS \$1076 VDD sg13g2_buf_8
X$3499 \$1293 VDD VSS \$786 \$1167 \$1375 sg13g2_nor3_2
X$3500 VDD VSS sg13g2_decap_4
X$3502 VDD VSS \$1292 \$1269 sg13g2_inv_1
X$3503 VDD VSS sg13g2_decap_8
X$3505 VDD VSS sg13g2_decap_8
X$3508 \$1271 VDD VSS sg13g2_tiehi
X$3509 VSS \$1271 \$1299 \$1212 \$1076 VDD sg13g2_dfrbpq_1
X$3515 \$1169 VSS \$1434 VDD \$1208 \$21 sg13g2_a21oi_1
X$3516 VDD VSS sg13g2_decap_8
X$3517 VDD VSS sg13g2_decap_8
X$3518 VDD VSS sg13g2_decap_8
X$3519 VDD VSS sg13g2_decap_8
X$3521 VDD VSS \$1213 \$1170 sg13g2_inv_1
X$3522 VDD VSS sg13g2_decap_8
X$3523 VDD VSS sg13g2_decap_8
X$3524 VDD VSS sg13g2_decap_8
X$3525 VDD VSS sg13g2_decap_8
X$3526 VDD VSS sg13g2_decap_8
X$3527 VDD VSS sg13g2_decap_8
X$3528 VDD VSS sg13g2_decap_8
X$3529 VDD VSS sg13g2_decap_8
X$3531 VSS \$1080 VDD \$975 sg13g2_buf_1
X$3532 VSS \$I34304 \$1004 VDD sg13g2_buf_16
X$3533 VDD VSS sg13g2_decap_8
X$3534 VDD VSS sg13g2_decap_8
X$3542 VSS \$1120 \$1309 \$1079 \$65 VDD sg13g2_dfrbpq_1
X$3543 VDD VSS sg13g2_decap_8
X$3544 VDD VSS sg13g2_decap_8
X$3545 \$1264 VDD VSS sg13g2_tiehi
X$3546 VDD VSS sg13g2_decap_8
X$3547 VDD VSS sg13g2_decap_8
X$3548 VDD VSS sg13g2_decap_8
X$3549 VDD VSS sg13g2_decap_4
X$3550 VSS \$1222 \$792 \$1220 \$1216 VDD sg13g2_mux2_1
X$3551 VSS \$1174 VDD \$1257 \$1317 \$910 \$1221 \$1222 sg13g2_a221oi_1
X$3552 VDD VSS \$1174 \$1122 \$1216 \$792 sg13g2_a21o_1
X$3553 VDD VSS sg13g2_decap_8
X$3556 VDD VSS \$1030 \$1217 sg13g2_inv_1
X$3557 VDD VSS sg13g2_decap_8
X$3558 VDD VSS sg13g2_decap_4
X$3559 VDD VSS \$1189 \$1081 \$1080 sg13g2_and2_1
X$3560 VSS \$1226 \$863 \$1123 \$1189 VDD sg13g2_mux2_1
X$3561 VDD VSS sg13g2_decap_8
X$3562 VDD VSS sg13g2_decap_8
X$3563 VDD VSS sg13g2_decap_4
X$3570 VDD VSS \$1183 \$1081 \$909 sg13g2_nand2_1
X$3571 VDD VSS sg13g2_decap_8
X$3572 VDD VSS sg13g2_decap_4
X$3574 \$1185 VSS \$1228 VDD \$1183 \$153 sg13g2_a21oi_1
X$3575 VDD VSS sg13g2_decap_8
X$3576 VDD VSS sg13g2_decap_8
X$3577 VDD VSS sg13g2_decap_8
X$3578 VDD VSS sg13g2_decap_8
X$3579 VDD VSS sg13g2_decap_8
X$3580 VDD VSS sg13g2_decap_8
X$3581 VDD VSS sg13g2_decap_8
X$3582 VDD VSS sg13g2_decap_8
X$3583 VDD VSS sg13g2_decap_8
X$3584 VDD VSS sg13g2_decap_4
X$3589 \$1279 VDD VSS sg13g2_tiehi
X$3590 VDD VSS \$1415 \$1362 \$674 sg13g2_nand2_1
X$3591 VSS \$1229 VDD \$1415 \$1328 \$1362 sg13g2_o21ai_1
X$3595 VDD VSS \$1328 \$1194 \$1193 sg13g2_nand2_1
X$3599 VDD VSS sg13g2_decap_8
X$3604 VDD VSS \$1559 \$1283 \$1334 sg13g2_nand2_1
X$3605 VDD VSS \$1283 \$1588 \$674 sg13g2_nand2_1
X$3608 VSS VDD \$1334 \$1193 \$1197 \$1196 sg13g2_nand3_1
X$3611 VDD VSS sg13g2_decap_8
X$3614 VDD VSS sg13g2_decap_8
X$3619 VDD VSS sg13g2_decap_8
X$3622 VDD VSS sg13g2_decap_8
X$3624 VDD VSS sg13g2_decap_4
X$3625 \$1338 VDD VSS sg13g2_tiehi
X$3626 VSS \$1338 \$1198 \$1396 \$1011 VDD sg13g2_dfrbpq_1
X$3645 VDD VSS sg13g2_decap_8
X$3646 VDD VSS sg13g2_decap_8
X$3649 VSS \$1362 VDD \$895 sg13g2_buf_1
X$3650 VDD VSS sg13g2_decap_8
X$3654 VDD VSS sg13g2_decap_8
X$3661 VDD VSS sg13g2_decap_8
X$3665 VDD VSS sg13g2_decap_8
X$3668 VDD VSS sg13g2_decap_8
X$3669 VDD VSS sg13g2_decap_4
X$3673 VSS VDD \$1350 \$1016 \$1012 \$1286 sg13g2_nand3_1
X$3675 VDD VSS \$1424 \$1111 \$1099 sg13g2_nand2_1
X$3678 VDD VSS \$1352 \$1424 \$1350 sg13g2_nand2_1
X$3682 VSS \$1203 \$1286 \$1352 \$1076 VDD sg13g2_dfrbpq_1
X$3686 VDD VSS sg13g2_decap_8
X$3687 VDD VSS sg13g2_decap_4
X$3690 VSS \$1197 VDD \$1023 sg13g2_buf_1
X$3691 VDD VSS sg13g2_decap_4
X$3695 VDD VSS \$1290 \$1375 \$1292 \$1293 \$1023 sg13g2_or4_1
X$3699 \$1292 VDD VSS \$1095 \$1208 \$1290 sg13g2_nor3_2
X$3706 VSS \$1076 \$789 VDD sg13g2_buf_16
X$3716 VDD VSS \$1167 \$1292 \$1347 sg13g2_nand2_1
X$3722 VDD \$1269 VSS \$898 \$1347 \$1374 \$1297 sg13g2_nand4_1
X$3724 VDD VSS \$1208 \$1374 \$1297 sg13g2_nand2_1
X$3726 VDD VSS \$1293 \$1301 \$1297 sg13g2_nor2_1
X$3727 VDD VSS \$1269 \$1375 \$1299 \$1293 \$1376 sg13g2_or4_1
X$3732 \$1212 VSS \$1376 VDD \$1300 \$1290 sg13g2_a21oi_1
X$3735 VDD VSS sg13g2_decap_8
X$3737 VDD VSS sg13g2_decap_8
X$3738 VDD VSS sg13g2_decap_4
X$3741 VDD VSS \$1434 \$1301 \$1433 sg13g2_nand2_1
X$3746 VDD VSS sg13g2_decap_8
X$3748 VDD VSS sg13g2_decap_8
X$3749 VDD VSS sg13g2_decap_8
X$3750 VDD VSS sg13g2_decap_8
X$3751 VDD VSS sg13g2_decap_8
X$3755 VDD VSS sg13g2_decap_8
X$3756 VDD VSS sg13g2_decap_8
X$3757 VDD VSS sg13g2_decap_8
X$3759 VDD VSS sg13g2_decap_8
X$3760 VDD VSS sg13g2_decap_8
X$3761 VDD VSS sg13g2_decap_8
X$3762 VDD VSS sg13g2_decap_8
X$3763 VDD VSS sg13g2_decap_8
X$3764 VDD VSS sg13g2_decap_4
X$3766 VDD VSS \$1309 \$1214 \$975 \$1494 sg13g2_or3_1
X$3769 \$1214 VDD VSS \$1531 \$1309 \$1080 sg13g2_nor3_2
X$3771 VDD VSS \$1438 \$1380 \$679 sg13g2_nand2b_1
X$3774 VDD VSS \$1440 \$1304 \$1443 sg13g2_nand2b_1
X$3777 VSS \$1380 VDD \$1608 \$1443 \$1257 sg13g2_o21ai_1
X$3780 VDD VSS \$453 \$1305 \$1306 \$1440 sg13g2_a21oi_2
X$3781 VDD VSS \$631 \$1445 \$1446 sg13g2_and2_1
X$3786 VDD VSS \$1304 \$1257 \$1896 sg13g2_nor2_1
X$3788 VDD VSS sg13g2_decap_8
X$3790 VSS \$1491 \$1214 \$863 \$1382 VDD sg13g2_mux2_1
X$3792 VDD VSS sg13g2_decap_8
X$3793 VDD VSS sg13g2_decap_8
X$3796 VSS \$1541 VDD \$1214 sg13g2_buf_1
X$3799 VDD VSS sg13g2_decap_8
X$3801 VSS \$1216 VDD \$1309 sg13g2_buf_1
X$3802 VDD VSS sg13g2_decap_4
X$3804 VSS VDD \$1312 \$1216 \$1541 sg13g2_nor2b_1
X$3806 VSS \$1122 VDD \$1304 \$1312 \$1217 \$1384 \$1220 sg13g2_a221oi_1
X$3815 VDD VSS \$1080 \$1385 \$1220 sg13g2_nor2_1
X$3823 VDD VSS sg13g2_decap_8
X$3829 VDD VSS sg13g2_decap_8
X$3835 VDD VSS sg13g2_decap_8
X$3836 VDD VSS sg13g2_decap_4
X$3841 VDD VSS \$1388 \$1385 \$1080 sg13g2_nand2_1
X$3844 \$1474 VSS \$863 VDD \$1221 \$1388 sg13g2_a21oi_1
X$3846 VSS VDD \$1329 \$910 \$1309 sg13g2_nor2b_1
X$3852 VDD VSS \$1309 \$1384 sg13g2_inv_1
X$3855 VSS \$1320 VDD \$1080 sg13g2_buf_1
X$3863 VSS \$1451 VDD \$1320 \$1384 \$1317 sg13g2_o21ai_1
X$3865 VDD VSS \$1385 \$1317 sg13g2_inv_1
X$3866 VDD VSS sg13g2_decap_4
X$3867 VSS VDD \$1322 \$1309 \$1081 sg13g2_nor2b_1
X$3870 VDD VSS sg13g2_decap_8
X$3874 VDD VSS sg13g2_decap_8
X$3879 VDD VSS sg13g2_decap_8
X$3880 VDD VSS sg13g2_decap_8
X$3886 VDD VSS sg13g2_decap_8
X$3887 VDD VSS sg13g2_decap_8
X$3888 VDD VSS sg13g2_decap_8
X$3889 VDD VSS sg13g2_decap_4
X$4144 VDD VSS sg13g2_decap_8
X$4145 VDD VSS sg13g2_decap_8
X$4146 VDD VSS sg13g2_decap_8
X$4147 VDD VSS sg13g2_decap_8
X$4153 VDD VSS sg13g2_decap_8
X$4154 VDD VSS sg13g2_decap_4
X$4156 \$1742 VDD VSS sg13g2_tiehi
X$4157 VDD VSS sg13g2_decap_4
X$4160 \$1509 VDD VSS sg13g2_tiehi
X$4161 VSS \$1509 \$1196 \$1559 \$1011 VDD sg13g2_dfrbpq_1
X$4164 VDD VSS sg13g2_decap_8
X$4165 VDD VSS sg13g2_decap_8
X$4166 VDD VSS sg13g2_decap_4
X$4168 \$1585 VDD VSS sg13g2_tiehi
X$4169 VSS \$1011 \$720 VDD sg13g2_buf_16
X$4170 VDD VSS sg13g2_decap_8
X$4171 VDD VSS sg13g2_decap_4
X$4173 \$1586 VDD VSS sg13g2_tiehi
X$4174 VDD VSS sg13g2_decap_8
X$4176 VSS \$1016 VDD \$1887 sg13g2_buf_1
X$4178 VDD VSS sg13g2_decap_8
X$4179 VSS VDD \$1421 \$1096 \$1016 \$1510 sg13g2_nand3_1
X$4180 VDD VSS \$1467 \$1587 \$1421 sg13g2_nand2_1
X$4181 VDD VSS \$1587 \$1095 \$1111 sg13g2_nand2_1
X$4182 VDD VSS \$1422 \$1512 \$1655 sg13g2_nand2_1
X$4189 VDD VSS \$1512 \$1111 \$1588 sg13g2_nand2_1
X$4191 VSS VDD \$1655 \$1016 \$1197 \$1514 sg13g2_nand3_1
X$4193 VSS \$1110 \$1589 \$1056 \$1510 \$1514 \$1286 \$1064 VDD sg13g2_mux4_1
X$4196 VDD VSS sg13g2_decap_4
X$4198 VSS \$I34311 \$789 VDD sg13g2_buf_16
X$4199 VDD VSS sg13g2_decap_8
X$4200 VDD VSS sg13g2_decap_8
X$4204 VSS \$1588 \$1292 \$1290 \$1293 \$1375 VDD sg13g2_nor4_2
X$4207 VDD VSS sg13g2_decap_4
X$4208 VDD VSS \$1167 \$1208 \$1099 sg13g2_nor2_1
X$4210 VDD VSS sg13g2_decap_8
X$4211 VDD VSS sg13g2_decap_8
X$4212 VDD VSS sg13g2_decap_8
X$4213 VDD VSS sg13g2_decap_8
X$4215 VDD VSS sg13g2_decap_8
X$4219 \$1301 \$1375 \$1374 VDD VSS sg13g2_nand2_2
X$4222 VDD VSS \$1596 \$1301 \$1374 sg13g2_and2_1
X$4225 \$1682 VSS \$1596 VDD \$1292 \$1027 sg13g2_a21oi_1
X$4227 VSS \$1300 VDD \$1299 \$1682 \$1688 sg13g2_o21ai_1
X$4233 VDD VSS sg13g2_decap_8
X$4235 VDD VSS sg13g2_decap_8
X$4237 VSS \$1433 VDD \$1526 \$1374 \$1027 sg13g2_o21ai_1
X$4238 VDD VSS sg13g2_decap_8
X$4241 VDD VSS sg13g2_decap_8
X$4242 VDD VSS sg13g2_decap_8
X$4243 VDD VSS sg13g2_decap_8
X$4244 VDD VSS sg13g2_decap_8
X$4245 VDD VSS sg13g2_decap_8
X$4246 VDD VSS sg13g2_decap_8
X$4247 VDD VSS sg13g2_decap_8
X$4248 VDD VSS sg13g2_decap_8
X$4249 VDD VSS sg13g2_decap_8
X$4250 VDD VSS sg13g2_decap_8
X$4251 VDD VSS sg13g2_decap_8
X$4252 VDD VSS \$1436 \$1603 \$1601 sg13g2_nand2b_1
X$4253 VDD VSS sg13g2_decap_8
X$4255 VDD VSS \$2077 \$1707 \$354 sg13g2_nand2b_1
X$4256 VDD VSS \$1545 \$1543 \$1528 \$1529 \$1707 sg13g2_nor4_1
X$4257 VDD VSS \$1603 \$1533 sg13g2_inv_1
X$4258 VDD \$1217 VSS \$1712 \$1436 \$1533 \$1531 sg13g2_nand4_1
X$4260 VSS \$1382 VDD \$1080 sg13g2_buf_1
X$4261 VDD VSS sg13g2_decap_8
X$4264 VDD VSS \$1608 \$1541 \$1534 sg13g2_nand2_1
X$4265 VSS VDD \$1538 \$1537 \$1440 \$1533 \$1541 sg13g2_and4_1
X$4272 VSS \$1539 VDD \$1446 \$1610 \$1538 \$1221 \$1534 sg13g2_a221oi_1
X$4275 VDD VSS sg13g2_decap_8
X$4279 VDD VSS \$1539 \$1531 \$1329 \$1491 sg13g2_a21o_1
X$4280 VDD VSS sg13g2_decap_8
X$4282 VDD VSS sg13g2_decap_8
X$4285 VSS \$1221 VDD \$1603 sg13g2_buf_1
X$4286 VDD VSS sg13g2_decap_4
X$4287 VSS \$1603 VDD \$1081 sg13g2_buf_1
X$4289 VDD VSS sg13g2_decap_8
X$4290 VDD VSS sg13g2_decap_8
X$4292 VDD VSS sg13g2_decap_8
X$4294 VSS \$1385 VDD \$1541 sg13g2_buf_1
X$4299 VSS \$I34325 \$688 VDD sg13g2_buf_16
X$4301 VDD VSS \$1221 \$1217 \$1216 \$1388 \$1628 sg13g2_nor4_1
X$4302 VDD VSS \$1388 \$1660 \$1533 \$910 sg13g2_nor3_1
X$4306 VDD VSS sg13g2_decap_8
X$4309 VDD VSS sg13g2_decap_4
X$4313 VSS \$1226 VDD \$1545 \$1385 \$1551 \$1533 \$1451 sg13g2_a221oi_1
X$4316 VSS \$1647 VDD \$1554 \$1634 \$1385 sg13g2_o21ai_1
X$4317 VDD VSS \$1551 \$910 \$1554 \$1322 sg13g2_a21o_1
X$4319 VDD VSS \$1385 \$1320 \$1554 sg13g2_nand2b_1
X$4325 VSS VDD \$1634 \$1320 \$1081 sg13g2_nor2b_1
X$4326 VDD VSS sg13g2_decap_8
X$4327 VDD VSS sg13g2_decap_8
X$4328 VDD VSS sg13g2_decap_8
X$4329 VDD VSS sg13g2_decap_8
X$4330 VDD VSS sg13g2_decap_8
X$4331 VDD VSS sg13g2_decap_8
X$4617 VDD VSS sg13g2_decap_8
X$4618 VDD VSS sg13g2_decap_8
X$4619 VDD VSS sg13g2_decap_8
X$4620 VDD VSS sg13g2_decap_8
X$4621 VDD VSS sg13g2_decap_4
X$4623 VDD VSS \$1791 \$1718 \$1834 sg13g2_nand2_1
X$4624 VSS \$1742 \$1885 \$1791 \$1011 VDD sg13g2_dfrbpq_1
X$4625 VDD VSS sg13g2_decap_8
X$4626 VDD VSS sg13g2_decap_4
X$4628 VDD VSS \$1794 \$779 \$1362 sg13g2_nand2_1
X$4629 VDD VSS sg13g2_decap_8
X$4631 VSS \$1838 VDD \$1794 \$1584 \$1362 sg13g2_o21ai_1
X$4633 VDD VSS \$1584 \$1721 \$1193 sg13g2_nand2_1
X$4635 VSS \$1585 \$1721 \$1838 \$1011 VDD sg13g2_dfrbpq_1
X$4636 VDD VSS sg13g2_decap_8
X$4637 VDD VSS sg13g2_decap_4
X$4639 VSS \$1586 \$1510 \$1467 \$1011 VDD sg13g2_dfrbpq_1
X$4640 VDD VSS sg13g2_decap_8
X$4641 \$1656 VDD VSS sg13g2_tiehi
X$4642 VSS \$1656 \$1514 \$1422 \$2107 VDD sg13g2_dfrbpq_1
X$4643 VDD VSS sg13g2_decap_8
X$4644 VDD VSS sg13g2_decap_4
X$4646 VDD VSS \$786 \$145 \$1722 sg13g2_nand2b_1
X$4647 VSS \$789 \$1620 VDD sg13g2_buf_16
X$4648 VSS \$1854 VDD \$1722 \$1805 \$786 sg13g2_o21ai_1
X$4649 VDD VSS sg13g2_decap_8
X$4650 VDD VSS sg13g2_decap_8
X$4651 VDD VSS sg13g2_decap_8
X$4652 VDD VSS sg13g2_decap_8
X$4653 VDD VSS sg13g2_decap_8
X$4654 VDD VSS sg13g2_decap_4
X$4656 VSS \$900 VDD \$1887 sg13g2_buf_1
X$4657 VDD VSS sg13g2_decap_8
X$4658 VDD VSS sg13g2_decap_8
X$4659 VDD VSS sg13g2_decap_8
X$4660 VDD VSS \$1787 \$1290 \$1594 sg13g2_nor2_1
X$4662 VDD VSS \$1293 \$1292 \$1595 sg13g2_nor2_1
X$4664 \$1787 VSS VDD \$1683 \$1596 \$1595 \$1292 sg13g2_a22oi_1
X$4667 VSS \$1683 VDD \$1526 \$1596 \$1027 sg13g2_o21ai_1
X$4668 VDD VSS sg13g2_decap_8
X$4669 VDD VSS sg13g2_decap_8
X$4670 VDD VSS sg13g2_decap_8
X$4672 VDD VSS sg13g2_decap_8
X$4673 VDD VSS sg13g2_decap_8
X$4674 VDD VSS sg13g2_decap_8
X$4675 VDD VSS sg13g2_decap_8
X$4676 VDD VSS \$1374 \$1599 \$1170 \$1725 sg13g2_a21oi_2
X$4677 VDD VSS sg13g2_decap_8
X$4678 VDD VSS \$1599 \$1726 \$1494 \$1601 \$1938 sg13g2_nor4_1
X$4679 VDD VSS \$1727 \$1726 \$1494 \$1601 \$1934 sg13g2_nor4_1
X$4680 VDD VSS \$1599 \$1601 \$1726 \$1494 \$1816 sg13g2_or4_1
X$4681 VDD VSS sg13g2_decap_8
X$4683 VSS \$1528 \$1727 \$1725 \$1712 \$1976 VDD sg13g2_nor4_2
X$4687 VSS \$765 \$1620 VDD sg13g2_buf_16
X$4689 VSS \$1445 VDD \$1440 \$1529 \$1528 sg13g2_o21ai_1
X$4690 VDD VSS sg13g2_decap_8
X$4692 VDD VSS \$1732 \$1526 \$1534 sg13g2_nor2_1
X$4695 VSS \$1305 VDD \$1826 \$1820 \$2093 sg13g2_o21ai_1
X$4696 VDD VSS \$1543 \$1610 \$1732 \$1533 sg13g2_nor3_1
X$4697 VDD VSS sg13g2_decap_4
X$4698 VDD VSS \$1534 \$1822 sg13g2_inv_1
X$4699 VDD VSS \$1822 \$1384 \$1306 sg13g2_nor2_1
X$4700 \$1824 VSS \$1539 VDD \$1221 \$1615 sg13g2_a21oi_1
X$4701 \$1615 VSS \$1537 VDD \$1541 \$1221 sg13g2_a21oi_1
X$4702 VSS \$1537 VDD \$1216 \$1382 \$1726 sg13g2_o21ai_1
X$4703 VDD VSS sg13g2_decap_8
X$4704 VDD VSS sg13g2_decap_8
X$4706 VDD VSS sg13g2_decap_8
X$4707 VDD VSS sg13g2_decap_8
X$4709 VDD VSS sg13g2_decap_4
X$4712 VDD VSS \$1382 \$1545 \$1622 sg13g2_nand2b_1
X$4713 VSS \$1830 VDD \$1622 \$1899 \$1845 sg13g2_o21ai_1
X$4714 VDD VSS sg13g2_decap_4
X$4716 VSS \$1726 VDD \$910 sg13g2_buf_1
X$4717 VSS \$688 \$1620 VDD sg13g2_buf_16
X$4720 VSS \$1913 VDD \$1826 \$1660 \$1628 \$1329 \$1647 sg13g2_a221oi_1
X$4724 VDD VSS \$1384 \$910 \$1474 \$1747 \$1845 sg13g2_nor4_1
X$4726 VSS VDD \$1632 \$1081 \$1329 \$1317 sg13g2_nand3_1
X$4727 \$2124 VSS \$1649 VDD \$1632 \$1320 sg13g2_a21oi_1
X$4728 VDD VSS sg13g2_decap_4
X$4730 VDD VSS \$1747 \$1317 \$1634 sg13g2_and2_1
X$4732 VSS VDD \$1649 \$1384 \$1739 \$910 sg13g2_nand3_1
X$4735 VDD VSS \$1739 \$1385 \$1081 sg13g2_nand2_1
X$4738 VDD VSS sg13g2_decap_8
X$4739 VDD VSS sg13g2_decap_8
X$4742 VDD VSS \$1832 \$229 \$1228 sg13g2_nand2b_1
X$4743 VDD VSS sg13g2_decap_8
X$4744 VDD VSS sg13g2_decap_8
X$4745 VDD VSS sg13g2_decap_8
X$4746 VDD VSS sg13g2_decap_4
X$5026 VDD VSS sg13g2_decap_8
X$5027 VDD VSS sg13g2_decap_8
X$5028 VDD VSS sg13g2_decap_8
X$5029 VDD VSS sg13g2_decap_8
X$5032 VDD VSS sg13g2_decap_4
X$5034 VDD VSS \$1883 \$779 \$1095 sg13g2_nand2_1
X$5036 VDD VSS \$1718 \$779 \$1099 sg13g2_nand2_1
X$5038 VDD VSS sg13g2_decap_8
X$5039 VDD VSS sg13g2_decap_8
X$5040 \$2121 VDD VSS sg13g2_tiehi
X$5042 VSS VDD \$1834 \$1951 \$1012 \$1885 sg13g2_nand3_1
X$5045 VDD VSS \$1915 \$2018 \$2021 sg13g2_nand2_1
X$5046 VDD VSS \$2018 \$779 \$1588 sg13g2_nand2_1
X$5049 VSS VDD \$2021 \$1193 \$1197 \$1952 sg13g2_nand3_1
X$5051 VDD VSS sg13g2_decap_8
X$5052 VDD VSS sg13g2_decap_8
X$5053 VDD VSS sg13g2_decap_8
X$5058 VDD VSS \$1011 \$I35507 sg13g2_inv_1
X$5060 VDD VSS sg13g2_decap_8
X$5062 VSS \$1951 VDD \$1193 sg13g2_buf_1
X$5064 VDD VSS sg13g2_decap_4
X$5066 VSS \$720 \$1620 VDD sg13g2_buf_16
X$5069 VDD VSS sg13g2_decap_8
X$5070 VDD VSS sg13g2_decap_8
X$5071 VDD VSS sg13g2_decap_8
X$5072 VDD VSS sg13g2_decap_8
X$5074 \$2133 VDD VSS sg13g2_tiehi
X$5075 VDD VSS sg13g2_decap_8
X$5080 VSS \$1929 VDD \$1964 \$1197 \$145 sg13g2_o21ai_1
X$5081 VSS VDD \$1964 \$1887 \$1197 \$1888 sg13g2_nand3_1
X$5082 VDD VSS sg13g2_decap_8
X$5083 VDD VSS sg13g2_decap_8
X$5084 VDD VSS sg13g2_decap_8
X$5086 \$2048 VDD VSS sg13g2_tiehi
X$5087 VSS \$2048 \$2108 \$1854 \$1076 VDD sg13g2_dfrbpq_1
X$5094 VDD VSS sg13g2_decap_8
X$5096 VDD VSS sg13g2_decap_8
X$5098 VDD VSS sg13g2_decap_4
X$5100 \$2056 VDD VSS sg13g2_tiehi
X$5101 VSS \$2056 \$1970 \$1594 \$2256 VDD sg13g2_dfrbpq_1
X$5105 VDD VSS \$1290 \$1347 sg13g2_inv_1
X$5108 VSS \$1292 VDD \$1970 sg13g2_buf_1
X$5109 VDD VSS sg13g2_decap_8
X$5112 VDD VSS sg13g2_decap_8
X$5114 \$1887 VSS \$1027 VDD \$1526 \$1290 sg13g2_a21oi_1
X$5118 VDD VSS sg13g2_decap_8
X$5122 VDD VSS sg13g2_decap_8
X$5123 VDD VSS sg13g2_decap_8
X$5125 VSS \$1599 VDD \$2259 \$1299 sg13g2_xor2_1
X$5128 VDD VSS sg13g2_decap_8
X$5129 VDD VSS sg13g2_decap_8
X$5130 VDD VSS sg13g2_decap_8
X$5131 VDD VSS sg13g2_decap_8
X$5132 VDD VSS sg13g2_decap_8
X$5137 VSS \$1894 \$1725 \$1938 \$1934 VDD sg13g2_mux2_1
X$5139 VDD VSS \$1727 \$1601 \$1726 \$1494 \$1975 sg13g2_or4_1
X$5140 VSS \$1820 \$1725 \$1816 \$1975 VDD sg13g2_mux2_2
X$5142 VSS \$1529 \$2160 \$1599 \$1712 \$1976 VDD sg13g2_nor4_2
X$5143 VDD VSS sg13g2_decap_8
X$5144 VDD VSS sg13g2_decap_4
X$5147 VDD VSS \$1820 \$1976 \$2084 sg13g2_nor2_1
X$5148 VDD VSS sg13g2_decap_8
X$5150 VDD VSS \$1438 \$1894 \$1440 \$1981 sg13g2_nand3b_1
X$5153 VSS \$1526 VDD \$2202 sg13g2_buf_1
X$5156 VDD VSS sg13g2_decap_8
X$5158 VDD VSS sg13g2_decap_4
X$5160 VDD VSS \$1981 \$1895 sg13g2_inv_1
X$5167 VDD VSS \$1895 \$1978 \$2055 sg13g2_nor2_1
X$5170 VDD VSS \$1984 \$1985 \$1541 sg13g2_xnor2_1
X$5173 \$1985 VSS \$1894 VDD \$1895 \$1896 sg13g2_a21oi_1
X$5176 VDD VSS sg13g2_decap_4
X$5178 \$1992 VDD VSS sg13g2_tiehi
X$5181 VSS \$1992 \$1998 \$1822 \$2456 VDD sg13g2_dfrbpq_1
X$5186 VDD VSS sg13g2_decap_8
X$5190 VDD VSS \$1994 \$1541 \$1382 sg13g2_and2_1
X$5192 VSS \$1994 VDD \$1899 \$1900 \$1216 \$2055 \$1894 sg13g2_a221oi_1
X$5195 VSS \$1900 VDD \$1221 \$1726 sg13g2_xor2_1
X$5197 VDD VSS sg13g2_decap_8
X$5200 VDD \$1221 VSS \$2284 \$792 \$1994 \$1329 sg13g2_nand4_1
X$5201 VDD VSS sg13g2_decap_4
X$5202 VDD VSS \$1913 \$1216 \$792 sg13g2_nand2_1
X$5203 VDD VSS sg13g2_decap_8
X$5206 VDD VSS sg13g2_decap_8
X$5207 VDD VSS sg13g2_decap_8
X$5210 VSS \$909 VDD \$1998 sg13g2_buf_1
X$5211 VDD VSS sg13g2_decap_8
X$5213 VDD VSS sg13g2_decap_8
X$5215 VDD VSS sg13g2_decap_8
X$5217 VDD VSS \$1905 \$1385 \$909 sg13g2_nand2_1
X$5220 VDD VSS sg13g2_decap_8
X$5221 VDD VSS sg13g2_decap_4
X$5223 \$2118 VDD VSS sg13g2_tiehi
X$5224 VDD VSS sg13g2_decap_8
X$5226 VDD VSS sg13g2_decap_8
X$5227 VDD VSS sg13g2_decap_8
X$5228 VDD VSS sg13g2_decap_8
X$5232 VDD VSS sg13g2_decap_8
X$5233 VDD VSS sg13g2_decap_8
X$5234 VDD VSS sg13g2_decap_8
X$5235 VDD VSS sg13g2_decap_4
X$5237 VSS VDD \$1946 \$1096 \$1951 \$2104 sg13g2_nand3_1
X$5241 VDD VSS \$2209 \$1883 \$1946 sg13g2_nand2_1
X$5244 VDD VSS sg13g2_decap_8
X$5255 VSS \$1949 VDD RESET sg13g2_buf_1
X$5258 VDD VSS sg13g2_decap_4
X$5261 VSS \$2121 \$1952 \$1915 \$2105 VDD sg13g2_dfrbpq_1
X$5283 VDD VSS \$2146 \$610 \$1588 sg13g2_nand2_1
X$5291 VSS \$1110 \$2030 \$1056 \$2104 \$1952 \$1885 \$1721 VDD sg13g2_mux4_1
X$5295 VDD VSS sg13g2_decap_8
X$5296 VDD VSS sg13g2_decap_8
X$5301 VSS \$130 VDD \$1949 sg13g2_buf_1
X$5304 VDD VSS sg13g2_decap_8
X$5307 VDD VSS \$2147 \$482 \$1588 sg13g2_nand2_1
X$5309 VDD VSS sg13g2_decap_8
X$5310 VDD VSS sg13g2_decap_8
X$5314 VSS \$1193 VDD \$1887 sg13g2_buf_1
X$5315 VDD VSS sg13g2_decap_8
X$5317 VDD VSS sg13g2_decap_8
X$5318 VDD VSS sg13g2_decap_8
X$5320 VSS \$2133 \$1888 \$1929 \$2107 VDD sg13g2_dfrbpq_1
X$5341 VDD VSS sg13g2_decap_8
X$5342 VDD VSS sg13g2_decap_8
X$5344 VDD VSS sg13g2_decap_8
X$5346 VDD VSS sg13g2_decap_8
X$5350 VDD VSS sg13g2_decap_4
X$5354 VDD VSS \$1805 \$2108 \$900 sg13g2_nand2_1
X$5355 VDD VSS sg13g2_decap_8
X$5358 VDD VSS sg13g2_decap_8
X$5359 VDD VSS sg13g2_decap_8
X$5363 VDD VSS sg13g2_decap_8
X$5364 VDD VSS sg13g2_decap_8
X$5365 VDD VSS sg13g2_decap_8
X$5369 VDD VSS sg13g2_decap_8
X$5372 VDD VSS sg13g2_decap_8
X$5376 VSS \$1290 VDD \$1949 sg13g2_buf_1
X$5377 VDD VSS sg13g2_decap_8
X$5383 VSS \$1971 VDD \$1970 \$2195 sg13g2_xor2_1
X$5387 VDD VSS sg13g2_decap_8
X$5388 VDD VSS sg13g2_decap_8
X$5392 VDD VSS sg13g2_decap_8
X$5395 VDD VSS sg13g2_decap_8
X$5399 VDD VSS sg13g2_decap_8
X$5400 VDD VSS sg13g2_decap_8
X$5405 VSS \$2109 VDD \$1301 \$2196 sg13g2_xor2_1
X$5407 VDD VSS sg13g2_decap_8
X$5408 VDD VSS sg13g2_decap_8
X$5409 VDD VSS sg13g2_decap_4
X$5410 \$2143 VDD VSS \$1725 \$2109 \$1971 sg13g2_nor3_2
X$5412 VDD VSS sg13g2_decap_4
X$5413 VDD VSS \$1971 \$2143 \$2109 \$1599 \$1972 sg13g2_nor4_1
X$5417 VDD VSS \$2158 \$1972 \$2159 \$2160 sg13g2_a21o_1
X$5423 VDD VSS sg13g2_decap_8
X$5434 VDD VSS sg13g2_decap_8
X$5440 VDD VSS sg13g2_decap_8
X$5444 VDD VSS sg13g2_decap_4
X$5448 \$2077 VSS \$2139 VDD \$2162 \$2143 sg13g2_a21oi_1
X$5451 VDD VSS \$1976 \$1981 \$1978 sg13g2_xnor2_1
X$5453 VDD VSS sg13g2_decap_4
X$5454 VDD VSS \$1382 \$2139 sg13g2_inv_1
X$5457 VDD VSS sg13g2_decap_8
X$5460 VDD VSS sg13g2_decap_8
X$5468 VDD VSS sg13g2_decap_8
X$5475 VDD VSS \$1981 \$1978 \$2093 sg13g2_nand2b_1
X$5477 VDD VSS sg13g2_decap_8
X$5481 VDD VSS sg13g2_decap_8
X$5492 VDD VSS sg13g2_decap_4
X$5494 VDD VSS \$2205 \$1984 \$1989 sg13g2_nor2_1
X$5500 \$1987 VSS \$1989 VDD \$1988 \$1822 sg13g2_a21oi_1
X$5509 VDD VSS sg13g2_decap_4
X$5513 VSS \$2769 VDD \$1726 \$1216 \$1382 sg13g2_o21ai_1
X$5519 VDD VSS sg13g2_decap_8
X$5522 VDD VSS sg13g2_decap_8
X$5524 VDD VSS sg13g2_decap_8
X$5525 VDD VSS sg13g2_decap_8
X$5529 VDD VSS \$2202 \$1726 \$1993 sg13g2_nor2_1
X$5532 VDD VSS \$1993 \$1732 \$1997 \$908 sg13g2_or3_1
X$5543 VDD VSS sg13g2_decap_8
X$5550 VDD VSS sg13g2_decap_8
X$5554 VDD VSS sg13g2_decap_8
X$5556 VDD VSS sg13g2_decap_4
X$5564 VDD VSS \$2116 \$2124 \$1997 sg13g2_nor2_1
X$5565 VDD VSS sg13g2_decap_8
X$5571 VDD VSS sg13g2_decap_8
X$5573 VDD VSS sg13g2_decap_8
X$5574 VDD VSS sg13g2_decap_8
X$5577 VDD VSS sg13g2_decap_8
X$5580 VDD VSS sg13g2_decap_8
X$5581 VDD VSS sg13g2_decap_8
X$5583 VDD VSS sg13g2_decap_4
X$5591 \$2163 VSS \$2009 VDD \$1905 \$153 sg13g2_a21oi_1
X$5594 VDD VSS \$2208 \$229 \$2009 sg13g2_nand2b_1
X$5595 VSS \$229 VDD \$1998 sg13g2_buf_1
X$5596 VSS \$2118 \$1832 \$2163 \$2292 VDD sg13g2_dfrbpq_1
X$5598 VDD VSS sg13g2_decap_4
X$5600 VSS \$2002 VDD FREEZE sg13g2_buf_1
X$5603 \$2296 VDD VSS sg13g2_tiehi
X$5604 VSS \$2296 \$2104 \$2209 \$2105 VDD sg13g2_dfrbpq_1
X$5615 VDD VSS sg13g2_decap_4
X$5618 VDD VSS \$2233 \$610 \$1099 sg13g2_nand2_1
X$5620 VDD VSS sg13g2_decap_8
X$5623 VDD VSS sg13g2_decap_8
X$5626 VDD VSS sg13g2_decap_8
X$5629 VDD VSS sg13g2_decap_8
X$5632 VDD VSS sg13g2_decap_8
X$5635 VSS VDD \$2235 \$1193 \$1197 \$2234 sg13g2_nand3_1
X$5641 VDD VSS \$2188 \$2146 \$2235 sg13g2_nand2_1
X$5645 \$2236 VDD VSS sg13g2_tiehi
X$5647 VDD VSS sg13g2_decap_8
X$5654 VDD VSS sg13g2_decap_8
X$5656 VDD VSS sg13g2_decap_8
X$5664 VDD VSS sg13g2_decap_8
X$5666 VDD VSS sg13g2_decap_8
X$5669 VDD VSS sg13g2_decap_4
X$5672 \$2239 VDD VSS sg13g2_tiehi
X$5673 VDD VSS \$2314 \$2147 \$2312 sg13g2_nand2_1
X$5680 VSS VDD \$2312 \$1951 \$1197 \$2380 sg13g2_nand3_1
X$5684 VDD VSS \$2190 \$482 \$1099 sg13g2_nand2_1
X$5685 VDD VSS sg13g2_decap_8
X$5690 VDD VSS sg13g2_decap_8
X$5693 VDD VSS sg13g2_decap_8
X$5694 VDD VSS sg13g2_decap_8
X$5695 VDD VSS sg13g2_decap_8
X$5698 VDD VSS sg13g2_decap_8
X$5701 VDD VSS sg13g2_decap_8
X$5704 VDD VSS sg13g2_decap_8
X$5707 VDD VSS sg13g2_decap_8
X$5708 VDD VSS sg13g2_decap_8
X$5709 VDD VSS sg13g2_decap_4
X$5711 VSS \$1110 \$2443 \$1056 \$2247 \$1888 \$2252 \$2108 VDD sg13g2_mux4_1
X$5721 VSS VDD \$2250 \$900 \$1012 \$2252 sg13g2_nand3_1
X$5724 VDD VSS sg13g2_decap_8
X$5726 VDD VSS sg13g2_decap_4
X$5728 \$2254 VDD VSS sg13g2_tiehi
X$5733 VSS \$2254 \$2195 \$2193 \$2256 VDD sg13g2_dfrbpq_1
X$5735 VDD VSS \$2193 \$900 \$2352 sg13g2_and2_1
X$5736 VDD VSS sg13g2_decap_4
X$5740 VDD VSS \$2352 \$2226 \$2195 sg13g2_xnor2_1
X$5743 VDD VSS \$2226 \$2196 \$2260 sg13g2_nand2_1
X$5745 VSS VDD \$2261 \$2195 \$2260 \$2196 sg13g2_nand3_1
X$5748 VDD VSS sg13g2_decap_4
X$5749 VDD VSS \$2153 \$1688 \$2260 sg13g2_nor2_1
X$5752 \$2264 VSS \$2223 VDD \$2391 \$1290 sg13g2_a21oi_1
X$5753 \$2153 VSS \$2266 VDD \$2267 \$1027 sg13g2_a21oi_1
X$5755 VSS VDD \$2223 \$2266 \$2198 \$2267 sg13g2_nand3_1
X$5758 VDD VSS \$1293 \$2196 \$2198 sg13g2_nor2_1
X$5760 VDD VSS sg13g2_decap_8
X$5763 VDD VSS sg13g2_decap_8
X$5764 VDD VSS sg13g2_decap_8
X$5772 VSS \$2143 VDD \$1949 sg13g2_buf_1
X$5775 VDD VSS \$2272 \$2143 \$2373 sg13g2_nor2_1
X$5778 VDD VSS sg13g2_decap_4
X$5780 \$2272 VSS \$1727 VDD \$1688 \$2274 sg13g2_a21oi_1
X$5784 VDD VSS \$1293 \$2158 \$2274 sg13g2_nor2_1
X$5792 VDD VSS \$2202 \$1027 \$1293 sg13g2_nand2b_1
X$5796 VDD VSS \$2109 \$2143 \$1971 \$2160 sg13g2_or3_1
X$5808 \$2267 VSS \$2160 VDD \$2159 \$1972 sg13g2_a21oi_1
X$5813 VDD VSS \$1727 \$2159 sg13g2_inv_1
X$5818 VDD VSS sg13g2_decap_8
X$5819 VDD VSS sg13g2_decap_8
X$5820 VDD VSS sg13g2_decap_4
X$5823 VDD VSS \$2202 \$2162 sg13g2_inv_1
X$5828 VSS \$1688 VDD \$2162 sg13g2_buf_1
X$5833 VSS \$2279 VDD \$2143 sg13g2_buf_1
X$5837 VDD VSS sg13g2_decap_8
X$5842 VDD VSS sg13g2_decap_8
X$5850 VDD VSS sg13g2_decap_4
X$5851 VSS \$1440 \$2279 \$1543 VDD sg13g2_nor2_2
X$5853 VDD VSS sg13g2_decap_8
X$5855 VDD VSS sg13g2_decap_8
X$5859 VDD VSS sg13g2_decap_8
X$5863 VDD VSS sg13g2_decap_8
X$5867 VDD VSS sg13g2_decap_4
X$5869 VDD VSS \$2322 \$1830 \$2084 \$2324 \$2205 sg13g2_or4_1
X$5877 VDD VSS sg13g2_decap_8
X$5882 VDD VSS sg13g2_decap_8
X$5888 VDD VSS sg13g2_decap_8
X$5890 VDD VSS sg13g2_decap_8
X$5891 VDD VSS sg13g2_decap_8
X$5892 VDD VSS sg13g2_decap_4
X$5893 VSS \$2202 VDD \$2283 sg13g2_buf_1
X$5894 VDD VSS sg13g2_decap_8
X$5899 VDD VSS sg13g2_decap_8
X$5905 VDD VSS sg13g2_decap_8
X$5911 VDD VSS sg13g2_decap_8
X$5913 \$2313 VDD VSS sg13g2_tiehi
X$5914 VDD VSS sg13g2_decap_8
X$5915 VSS VDD \$2116 \$2206 \$2284 \$2283 sg13g2_nand3_1
X$5922 VSS \$2283 VDD \$2002 sg13g2_buf_1
X$5923 VDD VSS \$1543 \$2002 \$2206 sg13g2_nand2_1
X$5924 VDD VSS sg13g2_decap_8
X$5925 VDD VSS sg13g2_decap_8
X$5926 VDD VSS sg13g2_decap_8
X$5928 \$2300 VDD VSS sg13g2_tiehi
X$5929 VSS \$2300 \$2208 \$2288 \$2292 VDD sg13g2_dfrbpq_1
X$5943 VDD VSS sg13g2_decap_8
X$5952 VDD VSS sg13g2_decap_8
X$5958 VDD VSS sg13g2_decap_8
X$5960 VDD VSS sg13g2_decap_8
X$5961 VDD VSS sg13g2_decap_8
X$5963 VDD VSS sg13g2_decap_8
X$5966 VDD VSS sg13g2_decap_8
X$5969 VDD VSS sg13g2_decap_8
X$5974 VDD VSS sg13g2_decap_8
X$5976 VDD VSS sg13g2_decap_8
X$5980 VDD VSS sg13g2_decap_8
X$5985 VDD VSS \$2379 \$2233 \$2302 sg13g2_nand2_1
X$5989 VDD VSS sg13g2_decap_8
X$5990 VDD VSS sg13g2_decap_8
X$5991 VDD VSS sg13g2_decap_4
X$5993 VSS VDD \$2302 \$1951 \$1012 \$2489 sg13g2_nand3_1
X$5994 VDD VSS sg13g2_decap_8
X$5995 VDD VSS sg13g2_decap_8
X$6002 VSS \$2236 \$2234 \$2188 \$1011 VDD sg13g2_dfrbpq_1
X$6008 VDD VSS sg13g2_decap_8
X$6009 VDD VSS sg13g2_decap_8
X$6012 VSS \$2239 \$2380 \$2314 \$2442 VDD sg13g2_dfrbpq_1
X$6028 VDD VSS \$2381 \$2190 \$2242 sg13g2_nand2_1
X$6029 VSS VDD \$2242 \$1887 \$1012 \$2498 sg13g2_nand3_1
X$6030 VDD VSS sg13g2_decap_8
X$6031 VDD VSS sg13g2_decap_8
X$6032 VDD VSS sg13g2_decap_8
X$6033 VDD VSS sg13g2_decap_8
X$6040 VSS \$2426 VDD \$2327 \$145 \$1096 sg13g2_o21ai_1
X$6041 VDD VSS sg13g2_decap_8
X$6042 VDD VSS sg13g2_decap_4
X$6044 VSS VDD \$2327 \$1096 \$1887 \$2247 sg13g2_nand3_1
X$6046 VDD VSS sg13g2_decap_4
X$6047 \$2249 VDD VSS sg13g2_tiehi
X$6048 VSS \$2502 VDD \$2250 \$1012 \$145 sg13g2_o21ai_1
X$6053 VSS \$2107 \$789 VDD sg13g2_buf_16
X$6068 VDD VSS sg13g2_decap_8
X$6069 VDD VSS sg13g2_decap_8
X$6075 VDD VSS sg13g2_decap_8
X$6077 VDD VSS sg13g2_decap_8
X$6080 VDD VSS sg13g2_decap_8
X$6085 VDD VSS sg13g2_decap_8
X$6091 VDD VSS sg13g2_decap_8
X$6098 VDD VSS sg13g2_decap_8
X$6108 VDD VSS \$2388 \$2261 \$2259 sg13g2_xnor2_1
X$6120 VDD VSS \$2390 \$900 \$2388 sg13g2_and2_1
X$6128 VSS \$2391 VDD \$2196 \$2153 \$1688 sg13g2_o21ai_1
X$6135 VSS \$2256 \$765 VDD sg13g2_buf_16
X$6161 VDD VSS sg13g2_decap_8
X$6163 \$2271 VDD VSS sg13g2_tiehi
X$6165 VSS \$2271 \$1727 \$2373 \$2256 VDD sg13g2_dfrbpq_1
X$6184 VDD VSS sg13g2_decap_8
X$6192 VDD VSS sg13g2_decap_8
X$6197 VDD VSS sg13g2_decap_8
X$6205 VDD VSS sg13g2_decap_8
X$6211 VDD VSS sg13g2_decap_8
X$6212 VDD VSS sg13g2_decap_8
X$6214 VDD VSS sg13g2_decap_8
X$6220 VDD VSS sg13g2_decap_8
X$6225 VDD VSS sg13g2_decap_8
X$6226 VDD VSS sg13g2_decap_8
X$6227 VDD VSS sg13g2_decap_8
X$6231 VDD VSS sg13g2_decap_8
X$6236 VDD VSS sg13g2_decap_8
X$6238 VSS \$1732 VDD \$2279 sg13g2_buf_1
X$6239 VDD VSS sg13g2_decap_8
X$6241 VDD VSS sg13g2_decap_8
X$6245 VDD VSS sg13g2_decap_8
X$6252 VDD VSS sg13g2_decap_8
X$6255 VDD VSS sg13g2_decap_8
X$6257 VDD VSS sg13g2_decap_8
X$6258 VDD VSS sg13g2_decap_8
X$6259 VDD VSS sg13g2_decap_8
X$6262 \$2396 VSS \$2404 VDD \$2398 \$1732 sg13g2_a21oi_1
X$6263 VDD VSS sg13g2_decap_8
X$6268 VDD VSS sg13g2_decap_4
X$6270 VDD VSS \$2431 \$2400 \$2399 sg13g2_nand2_1
X$6273 \$2423 VSS \$2402 VDD \$2431 \$1732 sg13g2_a21oi_1
X$6276 VDD VSS sg13g2_decap_8
X$6277 VSS \$2313 \$2403 \$2423 \$2456 VDD sg13g2_dfrbpq_1
X$6292 VDD VSS sg13g2_decap_8
X$6293 VDD VSS sg13g2_decap_8
X$6294 VDD VSS sg13g2_decap_8
X$6297 \$2288 VSS \$2289 VDD \$2416 \$153 sg13g2_a21oi_1
X$6304 VDD VSS \$2466 \$1998 \$2289 sg13g2_nand2b_1
X$6305 VDD VSS \$2291 \$1998 \$2404 sg13g2_nand2b_1
X$6307 VDD VSS sg13g2_decap_8
X$6311 VDD VSS sg13g2_decap_8
X$6313 VDD VSS sg13g2_decap_8
X$6314 VDD VSS sg13g2_decap_8
X$6315 VDD VSS sg13g2_decap_8
X$6316 VDD VSS sg13g2_decap_8
X$6317 VDD VSS sg13g2_decap_8
X$6318 VDD VSS sg13g2_decap_4
X$6321 VDD VSS sg13g2_decap_8
X$6322 VDD VSS sg13g2_decap_8
X$6323 VDD VSS sg13g2_decap_8
X$6324 VDD VSS sg13g2_decap_8
X$6327 VDD VSS sg13g2_decap_8
X$6329 \$2485 VDD VSS sg13g2_tiehi
X$6332 VSS \$2485 \$2489 \$2379 \$2105 VDD sg13g2_dfrbpq_1
X$6340 VDD VSS sg13g2_decap_8
X$6341 VDD VSS sg13g2_decap_8
X$6343 VDD VSS sg13g2_decap_8
X$6345 VDD VSS sg13g2_decap_8
X$6347 VDD VSS sg13g2_decap_8
X$6349 VDD VSS sg13g2_decap_8
X$6354 VDD VSS sg13g2_decap_8
X$6357 VDD VSS sg13g2_decap_8
X$6358 VDD VSS sg13g2_decap_8
X$6361 VDD VSS sg13g2_decap_8
X$6364 VDD VSS sg13g2_decap_8
X$6367 VDD VSS sg13g2_decap_8
X$6369 \$2550 VDD VSS sg13g2_tiehi
X$6372 VSS \$2550 \$2498 \$2381 \$2442 VDD sg13g2_dfrbpq_1
X$6385 VDD VSS sg13g2_decap_4
X$6389 \$2558 VDD VSS sg13g2_tiehi
X$6390 VSS \$2558 \$2247 \$2426 \$2107 VDD sg13g2_dfrbpq_1
X$6410 VSS \$2249 \$2252 \$2502 \$2107 VDD sg13g2_dfrbpq_1
X$6422 VDD VSS sg13g2_decap_8
X$6427 \$2503 VDD VSS sg13g2_tiehi
X$6428 VSS \$2503 \$1110 \$2193 \$2107 VDD sg13g2_dfrbpq_1
X$6438 VSS \$2446 \$2196 \$2264 \$2256 VDD sg13g2_dfrbpq_1
X$6446 \$2580 VDD VSS sg13g2_tiehi
X$6449 VSS \$2580 \$2259 \$2390 \$2256 VDD sg13g2_dfrbpq_1
X$6462 VDD VSS sg13g2_decap_8
X$6465 VDD VSS sg13g2_decap_8
X$6466 VDD VSS sg13g2_decap_8
X$6470 VDD VSS sg13g2_decap_8
X$6472 VDD VSS sg13g2_decap_4
X$6476 \$2638 VDD VSS sg13g2_tiehi
X$6477 VDD VSS sg13g2_decap_8
X$6478 VDD VSS sg13g2_decap_8
X$6481 VDD VSS sg13g2_decap_8
X$6483 VDD VSS sg13g2_decap_8
X$6484 VDD VSS sg13g2_decap_8
X$6490 VDD VSS sg13g2_decap_8
X$6491 VDD VSS sg13g2_decap_8
X$6492 VDD VSS sg13g2_decap_8
X$6494 VDD VSS sg13g2_decap_8
X$6495 VDD VSS sg13g2_decap_8
X$6498 VDD VSS sg13g2_decap_8
X$6499 VDD VSS sg13g2_decap_8
X$6500 VDD VSS sg13g2_decap_4
X$6502 VDD VSS \$2451 \$2279 \$2471 sg13g2_nor2_1
X$6503 VSS \$2451 VDD \$2474 \$2510 \$2202 sg13g2_o21ai_1
X$6504 VDD VSS \$2474 \$2511 \$2202 \$2322 sg13g2_nand3b_1
X$6509 VSS \$2454 \$2400 \$2471 \$2456 VDD sg13g2_dfrbpq_1
X$6512 VDD VSS sg13g2_decap_8
X$6514 VDD VSS sg13g2_decap_8
X$6515 VDD VSS sg13g2_decap_8
X$6516 VDD VSS sg13g2_decap_4
X$6517 \$2541 VDD VSS sg13g2_tiehi
X$6518 VSS \$2541 \$2458 \$2396 \$2456 VDD sg13g2_dfrbpq_1
X$6531 VDD VSS \$2458 \$2399 \$2402 sg13g2_nand2b_1
X$6543 VSS \$2460 VDD \$1732 sg13g2_buf_1
X$6545 VDD VSS sg13g2_decap_8
X$6548 VDD VSS sg13g2_decap_8
X$6550 VDD VSS sg13g2_decap_8
X$6553 \$2516 VSS \$2461 VDD \$2517 \$2460 sg13g2_a21oi_1
X$6555 VDD VSS \$2403 \$2399 \$2461 sg13g2_nand2b_1
X$6558 VSS \$2519 \$2466 \$2516 \$2292 VDD sg13g2_dfrbpq_1
X$6571 VDD VSS sg13g2_decap_8
X$6579 VDD VSS sg13g2_decap_8
X$6582 VDD VSS sg13g2_decap_4
X$6583 VSS \$153 VDD \$2460 sg13g2_buf_1
X$6587 \$2526 VDD VSS sg13g2_tiehi
X$6588 VSS \$2526 \$2291 \$2778 \$2292 VDD sg13g2_dfrbpq_1
X$6590 VDD VSS sg13g2_decap_4
X$6592 VDD VSS sg13g2_decap_8
X$6593 VDD VSS sg13g2_decap_8
X$6594 VDD VSS sg13g2_decap_8
X$6596 VDD VSS \$2675 \$2584 \$2483 sg13g2_nand2_1
X$6597 VSS VDD \$2483 \$1096 \$1951 \$2484 sg13g2_nand3_1
X$6601 VDD VSS sg13g2_decap_4
X$6602 VDD VSS \$2584 \$1095 \$610 sg13g2_nand2_1
X$6603 VDD VSS sg13g2_decap_8
X$6607 VDD VSS sg13g2_decap_8
X$6608 VDD VSS sg13g2_decap_4
X$6611 VDD VSS \$2588 \$610 \$1362 sg13g2_nand2_1
X$6612 VSS \$2879 VDD \$2588 \$2618 \$1362 sg13g2_o21ai_1
X$6614 VDD VSS sg13g2_decap_4
X$6616 VSS \$1110 \$2727 \$1056 \$2484 \$2234 \$2489 \$2744 VDD sg13g2_mux4_1
X$6617 VDD VSS sg13g2_decap_8
X$6618 VDD VSS sg13g2_decap_8
X$6620 VDD VSS sg13g2_decap_8
X$6621 VSS \$2680 VDD \$2540 \$2590 \$1362 sg13g2_o21ai_1
X$6622 VDD VSS sg13g2_decap_4
X$6623 VDD VSS \$2590 \$2494 \$1951 sg13g2_nand2_1
X$6624 VDD VSS \$2540 \$482 \$1362 sg13g2_nand2_1
X$6625 VDD VSS sg13g2_decap_4
X$6626 VDD VSS \$2699 \$1095 \$482 sg13g2_nand2_1
X$6627 VSS VDD \$2650 \$1096 \$1951 \$2595 sg13g2_nand3_1
X$6630 VSS \$1110 \$2688 \$1056 \$2595 \$2380 \$2498 \$2494 VDD sg13g2_mux4_1
X$6640 VDD VSS sg13g2_decap_8
X$6644 VDD VSS sg13g2_decap_8
X$6647 VDD VSS sg13g2_decap_8
X$6651 VDD VSS sg13g2_decap_8
X$6656 VDD VSS sg13g2_decap_8
X$6659 VDD VSS sg13g2_decap_8
X$6661 VDD VSS sg13g2_decap_8
X$6662 VDD VSS sg13g2_decap_8
X$6665 VDD VSS sg13g2_decap_8
X$6667 VDD VSS sg13g2_decap_8
X$6669 VDD VSS sg13g2_decap_8
X$6673 \$2567 VDD VSS sg13g2_tiehi
X$6674 VSS \$2567 \$1056 \$2264 \$2107 VDD sg13g2_dfrbpq_1
X$6681 VDD VSS sg13g2_decap_8
X$6682 VDD VSS sg13g2_decap_4
X$6686 \$2446 VDD VSS sg13g2_tiehi
X$6689 VDD VSS sg13g2_decap_8
X$6691 VDD VSS sg13g2_decap_8
X$6694 VDD VSS sg13g2_decap_8
X$6695 VDD VSS sg13g2_decap_8
X$6697 VDD VSS sg13g2_decap_8
X$6704 VDD VSS \$2256 \$I35525 sg13g2_inv_1
X$6706 VDD VSS sg13g2_decap_8
X$6712 VDD VSS sg13g2_decap_8
X$6713 VDD VSS sg13g2_decap_8
X$6716 VDD VSS sg13g2_decap_8
X$6718 VDD VSS sg13g2_decap_8
X$6719 VDD VSS sg13g2_decap_8
X$6720 VSS \$2653 VDD \$1347 sg13g2_buf_1
X$6721 VSS \$2638 \$2694 \$2575 \$2256 VDD sg13g2_dfrbpq_1
X$6723 VDD VSS sg13g2_decap_8
X$6724 VDD VSS \$2507 \$2202 \$2506 sg13g2_nor2_1
X$6725 VSS \$2575 VDD \$2653 \$2506 \$2600 sg13g2_o21ai_1
X$6729 VSS \$2510 VDD \$2400 sg13g2_buf_1
X$6730 VDD VSS \$2663 \$1688 \$2508 \$2657 \$2600 sg13g2_nor4_1
X$6732 VDD VSS \$2658 \$2568 \$2508 \$2507 sg13g2_nor3_1
X$6734 VDD VSS \$1988 \$2568 \$2507 \$2663 sg13g2_a21o_1
X$6735 VDD VSS sg13g2_decap_8
X$6736 VDD VSS sg13g2_decap_8
X$6737 VDD VSS sg13g2_decap_8
X$6739 VDD VSS sg13g2_decap_8
X$6747 VDD VSS sg13g2_decap_8
X$6755 VDD VSS sg13g2_decap_8
X$6764 \$2454 VDD VSS sg13g2_tiehi
X$6769 VDD VSS sg13g2_decap_8
X$6772 VDD VSS sg13g2_decap_8
X$6774 VDD VSS sg13g2_decap_8
X$6777 VDD VSS sg13g2_decap_8
X$6778 VDD VSS sg13g2_decap_8
X$6779 VDD VSS sg13g2_decap_8
X$6780 VDD VSS sg13g2_decap_8
X$6786 VDD VSS \$2398 \$2604 \$2399 sg13g2_nand2_1
X$6789 VDD VSS sg13g2_decap_8
X$6793 VDD VSS \$2456 \$I35517 sg13g2_inv_1
X$6795 VSS \$2456 \$688 VDD sg13g2_buf_16
X$6807 VDD VSS \$2517 \$2515 \$2399 sg13g2_nand2_1
X$6808 VDD VSS sg13g2_decap_8
X$6809 VDD VSS sg13g2_decap_8
X$6814 VDD VSS sg13g2_decap_8
X$6822 VDD VSS sg13g2_decap_4
X$6827 \$2519 VDD VSS sg13g2_tiehi
X$6829 VDD VSS sg13g2_decap_8
X$6832 VDD VSS sg13g2_decap_8
X$6833 VDD VSS sg13g2_decap_8
X$6835 VDD VSS sg13g2_decap_8
X$6837 VDD VSS sg13g2_decap_8
X$6844 VSS \$2292 \$688 VDD sg13g2_buf_16
X$6853 VDD VSS \$2673 \$2671 sg13g2_inv_1
X$6854 VDD VSS sg13g2_decap_8
X$6855 VDD VSS sg13g2_decap_8
X$7070 \$2741 VDD VSS sg13g2_tiehi
X$7072 VSS \$2741 \$2484 \$2675 \$2105 VDD sg13g2_dfrbpq_1
X$7080 VDD VSS sg13g2_decap_8
X$7081 VDD VSS sg13g2_decap_8
X$7082 VDD VSS sg13g2_decap_4
X$7084 VSS \$2105 \$720 VDD sg13g2_buf_16
X$7086 VDD VSS \$2618 \$2744 \$1951 sg13g2_nand2_1
X$7088 VDD VSS sg13g2_decap_8
X$7089 VDD VSS sg13g2_decap_8
X$7090 VDD VSS sg13g2_decap_4
X$7092 VSS \$2745 \$2494 \$2680 \$2105 VDD sg13g2_dfrbpq_1
X$7095 VDD VSS sg13g2_decap_8
X$7098 VDD VSS \$2821 \$2699 \$2650 sg13g2_nand2_1
X$7101 VSS \$2442 \$720 VDD sg13g2_buf_16
X$7102 VDD VSS sg13g2_decap_8
X$7103 VDD VSS sg13g2_decap_8
X$7109 VDD VSS sg13g2_decap_8
X$7110 VDD VSS sg13g2_decap_4
X$7112 VSS \$2794 \$1981 \$2940 \$2107 VDD sg13g2_dfrbpq_1
X$7113 VDD VSS sg13g2_decap_8
X$7114 VDD VSS sg13g2_decap_8
X$7116 VDD VSS \$2749 \$2266 \$2443 sg13g2_nand2_1
X$7117 \$2824 VDD VSS sg13g2_tiehi
X$7118 VDD VSS sg13g2_decap_8
X$7119 VDD VSS sg13g2_decap_8
X$7120 VDD VSS sg13g2_decap_8
X$7121 VDD VSS sg13g2_decap_8
X$7122 VDD VSS sg13g2_decap_8
X$7123 VDD VSS sg13g2_decap_8
X$7124 VDD VSS sg13g2_decap_8
X$7125 VDD VSS sg13g2_decap_8
X$7127 VDD VSS \$2652 \$2266 \$1118 sg13g2_nand2_1
X$7128 VDD VSS sg13g2_decap_8
X$7129 VDD VSS sg13g2_decap_8
X$7130 VDD VSS sg13g2_decap_8
X$7131 VDD VSS sg13g2_decap_8
X$7132 VDD VSS sg13g2_decap_8
X$7138 VDD VSS sg13g2_decap_8
X$7139 VDD VSS sg13g2_decap_8
X$7140 VDD VSS sg13g2_decap_8
X$7141 VDD VSS sg13g2_decap_8
X$7142 VDD VSS sg13g2_decap_8
X$7143 VDD VSS sg13g2_decap_8
X$7144 VDD VSS sg13g2_decap_8
X$7145 VDD VSS sg13g2_decap_8
X$7146 VDD VSS sg13g2_decap_8
X$7147 VDD VSS sg13g2_decap_8
X$7149 VSS \$2507 VDD \$2694 sg13g2_buf_1
X$7150 VDD VSS sg13g2_decap_8
X$7152 VDD VSS \$2707 \$2657 \$2754 \$2507 sg13g2_nor3_1
X$7153 VDD VSS sg13g2_decap_4
X$7154 VDD VSS \$2707 \$2754 \$2658 sg13g2_nor2_1
X$7155 VSS \$2691 \$2507 \$2400 VDD sg13g2_nor2_2
X$7157 VDD VSS \$2751 \$2663 \$2206 \$2510 sg13g2_nor3_1
X$7159 VDD VSS sg13g2_decap_4
X$7160 \$2763 VSS \$2711 VDD \$2158 \$2709 sg13g2_a21oi_1
X$7161 VSS VDD \$2508 \$2712 \$2763 sg13g2_nor2b_1
X$7162 VDD VSS sg13g2_decap_8
X$7163 VDD VSS sg13g2_decap_8
X$7164 VDD VSS sg13g2_decap_8
X$7165 VDD VSS sg13g2_decap_8
X$7166 VDD VSS sg13g2_decap_8
X$7173 VDD VSS \$2711 \$2709 \$2715 sg13g2_nor2_1
X$7177 VDD VSS \$2767 \$2715 \$2768 \$1824 \$2324 sg13g2_or4_1
X$7178 VDD VSS sg13g2_decap_8
X$7179 VDD VSS sg13g2_decap_8
X$7180 VDD VSS sg13g2_decap_8
X$7181 VDD VSS sg13g2_decap_8
X$7182 VDD VSS sg13g2_decap_8
X$7183 VDD VSS sg13g2_decap_8
X$7184 VDD VSS sg13g2_decap_8
X$7185 VDD VSS sg13g2_decap_8
X$7186 \$2771 VSS \$2773 VDD \$2772 \$1732 sg13g2_a21oi_1
X$7187 VDD VSS sg13g2_decap_8
X$7190 \$2774 VDD VSS sg13g2_tiehi
X$7191 VDD VSS sg13g2_decap_8
X$7192 VDD VSS sg13g2_decap_8
X$7193 VDD VSS sg13g2_decap_8
X$7194 VDD VSS sg13g2_decap_8
X$7195 VDD VSS sg13g2_decap_8
X$7196 VDD VSS sg13g2_decap_8
X$7197 VDD VSS sg13g2_decap_8
X$7199 \$2776 VDD VSS sg13g2_tiehi
X$7200 VDD VSS sg13g2_decap_8
X$7206 VDD VSS sg13g2_decap_8
X$7208 \$2783 VDD VSS sg13g2_tiehi
X$7209 VDD VSS \$2671 \$2778 \$2460 \$1998 sg13g2_nor3_1
X$7210 VSS \$2783 \$2673 \$2779 \$2292 VDD sg13g2_dfrbpq_1
X$7211 VDD VSS sg13g2_decap_4
X$7212 VDD VSS sg13g2_decap_8
X$7215 VDD VSS sg13g2_decap_8
X$7219 VDD VSS sg13g2_decap_8
X$7221 VDD VSS sg13g2_decap_8
X$7225 VDD VSS sg13g2_decap_8
X$7227 VDD VSS sg13g2_decap_8
X$7229 VDD VSS sg13g2_decap_4
X$7231 VSS \$2936 VDD \$1949 sg13g2_buf_1
X$7233 VDD VSS sg13g2_decap_4
X$7235 \$2787 VDD VSS sg13g2_tiehi
X$7237 VSS \$2787 \$2744 \$2879 \$2105 VDD sg13g2_dfrbpq_1
X$7245 VDD VSS sg13g2_decap_8
X$7247 VDD VSS sg13g2_decap_8
X$7248 VDD VSS sg13g2_decap_4
X$7252 \$2745 VDD VSS sg13g2_tiehi
X$7254 VDD VSS sg13g2_decap_8
X$7255 VDD VSS sg13g2_decap_8
X$7259 VDD VSS sg13g2_decap_8
X$7263 VDD VSS sg13g2_decap_4
X$7265 VDD VSS \$2840 \$2841 \$1188 sg13g2_and2_1
X$7270 \$2747 VDD VSS sg13g2_tiehi
X$7275 VSS \$2747 \$2595 \$2821 \$2442 VDD sg13g2_dfrbpq_1
X$7280 VDD VSS sg13g2_decap_8
X$7281 VDD VSS sg13g2_decap_8
X$7282 VDD VSS sg13g2_decap_8
X$7283 VDD VSS sg13g2_decap_8
X$7285 \$2794 VDD VSS sg13g2_tiehi
X$7287 VDD VSS sg13g2_decap_8
X$7291 VDD VSS \$3168 \$2841 \$1589 sg13g2_nand2_1
X$7292 VDD VSS sg13g2_decap_8
X$7295 VDD VSS sg13g2_decap_8
X$7297 VSS \$2841 VDD \$2266 sg13g2_buf_1
X$7299 VDD VSS sg13g2_decap_4
X$7300 VSS \$2824 \$1436 \$2885 \$2107 VDD sg13g2_dfrbpq_1
X$7309 VDD VSS sg13g2_decap_8
X$7310 VDD VSS sg13g2_decap_8
X$7311 VDD VSS sg13g2_decap_8
X$7312 VDD VSS sg13g2_decap_8
X$7313 VDD VSS sg13g2_decap_8
X$7316 \$2799 VDD VSS sg13g2_tiehi
X$7321 VDD VSS sg13g2_decap_4
X$7323 VSS \$2799 \$2825 \$2889 \$2256 VDD sg13g2_dfrbpq_1
X$7325 VDD VSS \$2893 \$2826 \$2266 sg13g2_nor2_1
X$7328 VDD VSS \$2893 \$2953 \$2825 sg13g2_xnor2_1
X$7329 VDD VSS sg13g2_decap_8
X$7331 VDD VSS \$2826 \$2825 \$2751 sg13g2_nand2b_1
X$7332 VDD VSS sg13g2_decap_8
X$7333 VDD VSS sg13g2_decap_8
X$7335 VDD VSS sg13g2_decap_8
X$7336 VDD VSS sg13g2_decap_8
X$7337 VDD VSS sg13g2_decap_8
X$7338 VDD VSS sg13g2_decap_8
X$7339 VDD VSS sg13g2_decap_8
X$7341 VDD VSS sg13g2_decap_8
X$7347 VDD VSS sg13g2_decap_4
X$7350 VSS VDD \$2753 \$2829 \$2827 \$2828 sg13g2_nand3_1
X$7355 VSS \$2754 VDD \$2753 \$2829 \$2828 sg13g2_o21ai_1
X$7361 VDD VSS \$2764 \$2707 \$2827 \$2829 sg13g2_nor3_1
X$7366 VSS VDD \$2709 \$2827 \$2691 \$2829 sg13g2_nand3_1
X$7380 VDD VSS \$2851 \$2507 \$2510 sg13g2_nand2_1
X$7389 VDD VSS sg13g2_decap_8
X$7393 VDD VSS sg13g2_decap_4
X$7400 VDD VSS \$2711 \$2206 \$2764 sg13g2_nor2_1
X$7405 VDD \$2515 VSS \$2923 \$2920 \$2691 \$2764 sg13g2_nand4_1
X$7406 VDD VSS sg13g2_decap_4
X$7408 VSS \$2322 VDD \$2923 \$2820 \$2510 sg13g2_o21ai_1
X$7411 VDD VSS \$2820 \$2507 \$2827 sg13g2_nand2_1
X$7413 VDD VSS sg13g2_decap_8
X$7414 VDD VSS sg13g2_decap_4
X$7416 VSS \$2604 VDD \$2507 sg13g2_buf_1
X$7422 VDD VSS sg13g2_decap_8
X$7427 VDD VSS sg13g2_decap_8
X$7431 VDD VSS sg13g2_decap_8
X$7432 VDD VSS sg13g2_decap_8
X$7433 VDD VSS sg13g2_decap_8
X$7434 VDD VSS sg13g2_decap_8
X$7437 VDD VSS sg13g2_decap_4
X$7439 VDD VSS \$2835 \$1732 \$2711 \$2963 sg13g2_or3_1
X$7441 \$2965 VDD VSS sg13g2_tiehi
X$7442 VDD VSS sg13g2_decap_8
X$7445 VDD VSS \$2772 \$2913 \$2399 sg13g2_nand2_1
X$7452 VDD VSS \$2901 \$2399 \$2773 sg13g2_nand2b_1
X$7457 VSS \$2774 \$2897 \$2771 \$2456 VDD sg13g2_dfrbpq_1
X$7461 VDD VSS \$2897 \$2864 \$3057 sg13g2_nor2_1
X$7462 VDD VSS sg13g2_decap_8
X$7463 VDD VSS sg13g2_decap_4
X$7464 VDD VSS \$2416 \$2920 \$2864 sg13g2_nand2_1
X$7465 VDD VSS sg13g2_decap_8
X$7466 VDD VSS sg13g2_decap_4
X$7467 VSS \$2776 \$2777 \$2868 \$2292 VDD sg13g2_dfrbpq_1
X$7472 VDD VSS \$2777 \$1998 \$2871 sg13g2_nand2b_1
X$7478 \$2779 VSS \$2871 VDD \$2869 \$2460 sg13g2_a21oi_1
X$7482 VDD VSS sg13g2_decap_8
X$7483 VDD VSS sg13g2_decap_8
X$7486 VDD VSS sg13g2_decap_8
X$7489 VDD VSS sg13g2_decap_4
X$7490 VDD VSS sg13g2_decap_8
X$7491 VDD VSS sg13g2_decap_4
X$7493 VSS \$3196 \$2984 \$3052 \$3053 VDD sg13g2_mux2_1
X$7494 VSS VDD \$3052 \$2936 \$3197 sg13g2_nor2b_1
X$7497 VDD VSS sg13g2_decap_4
X$7498 \$3063 VDD VSS sg13g2_tiehi
X$7499 VSS \$3063 \$2937 \$2968 \$2105 VDD sg13g2_dfrbpq_1
X$7507 \$1949 \$2968 \$2937 VDD VSS sg13g2_or2_1
X$7512 VDD VSS sg13g2_decap_8
X$7514 VDD VSS sg13g2_decap_8
X$7515 VDD VSS sg13g2_decap_8
X$7517 VDD VSS sg13g2_decap_4
X$7519 VSS \$3234 \$2984 \$3068 \$2944 VDD sg13g2_mux2_1
X$7520 VDD VSS sg13g2_decap_8
X$7526 VDD VSS sg13g2_decap_8
X$7527 VDD VSS sg13g2_decap_8
X$7528 VDD VSS sg13g2_decap_8
X$7530 VDD VSS \$4097 \$2841 \$2727 sg13g2_nand2_1
X$7532 VDD VSS \$2939 \$2841 \$2030 sg13g2_nand2_1
X$7535 VDD VSS sg13g2_decap_8
X$7538 VSS \$2442 VDD sg13g2_buf_8
X$7541 VDD VSS sg13g2_decap_8
X$7542 VDD VSS sg13g2_decap_8
X$7544 VDD VSS sg13g2_decap_8
X$7545 VDD VSS sg13g2_decap_8
X$7548 VDD VSS sg13g2_decap_8
X$7549 VDD VSS sg13g2_decap_4
X$7551 \$2940 VSS \$3077 VDD \$2989 \$2988 sg13g2_a21oi_1
X$7553 VDD VSS \$2941 \$2841 \$1254 sg13g2_nand2_1
X$7554 VDD VSS \$3077 \$1981 \$2990 sg13g2_nand2_1
X$7556 VDD VSS \$2842 \$1981 \$2996 sg13g2_nand2_1
X$7561 VDD VSS \$2992 \$2993 \$2841 \$2688 sg13g2_a21o_1
X$7562 VDD VSS sg13g2_decap_8
X$7563 VDD VSS sg13g2_decap_4
X$7567 VDD VSS \$2944 \$2749 \$2945 sg13g2_nand2_1
X$7570 VDD VSS sg13g2_decap_8
X$7572 \$2885 VSS \$3096 VDD \$2945 \$2988 sg13g2_a21oi_1
X$7575 VDD VSS sg13g2_decap_4
X$7577 VDD VSS \$3096 \$1436 \$2990 \$2996 sg13g2_nand3b_1
X$7584 VDD VSS sg13g2_decap_8
X$7585 VDD VSS sg13g2_decap_8
X$7586 VDD VSS sg13g2_decap_8
X$7587 VDD VSS sg13g2_decap_8
X$7588 VDD VSS sg13g2_decap_8
X$7590 VDD VSS \$2946 \$2988 \$3260 sg13g2_nor2_1
X$7591 \$2946 VSS \$2990 VDD \$3001 \$2993 sg13g2_a21oi_1
X$7594 VDD VSS sg13g2_decap_8
X$7598 VDD VSS sg13g2_decap_8
X$7599 VDD VSS sg13g2_decap_8
X$7601 VDD VSS sg13g2_decap_8
X$7604 VDD VSS \$3107 \$2889 sg13g2_inv_1
X$7608 VDD VSS \$2826 \$2825 \$3001 \$3206 \$2996 sg13g2_nor4_1
X$7614 VDD VSS sg13g2_decap_4
X$7621 VSS \$3012 VDD \$2825 sg13g2_buf_1
X$7624 VDD VSS \$2825 \$2829 sg13g2_inv_1
X$7627 \$3624 VSS \$3007 VDD \$2952 \$1949 sg13g2_a21oi_1
X$7633 VDD \$2951 VSS \$3007 \$2902 \$2948 \$2846 sg13g2_nand4_1
X$7634 \$2826 \$2951 VSS VDD sg13g2_inv_2
X$7636 VDD VSS \$2902 \$2828 \$2829 sg13g2_nand2_1
X$7637 VSS \$2827 VDD \$2951 sg13g2_buf_1
X$7639 VDD VSS \$2846 \$3012 \$2953 sg13g2_nand2_1
X$7640 VSS \$2990 VDD \$2952 sg13g2_buf_1
X$7643 VDD VSS \$2952 \$3018 \$2691 sg13g2_nand2_1
X$7644 VDD VSS \$2951 \$3012 \$3018 sg13g2_nor2_1
X$7645 VDD VSS sg13g2_decap_8
X$7647 VDD VSS \$2953 \$2694 \$2400 sg13g2_and2_1
X$7652 VDD VSS sg13g2_decap_8
X$7653 VSS \$2515 VDD \$3012 sg13g2_buf_1
X$7660 VDD VSS sg13g2_decap_8
X$7668 VDD VSS sg13g2_decap_4
X$7678 VDD VSS \$2515 \$1688 \$3022 sg13g2_nor2_1
X$7686 VSS \$2970 VDD \$3107 \$3022 \$2279 \$2515 \$3126 sg13g2_a221oi_1
X$7692 VDD VSS \$2970 \$2851 \$2926 sg13g2_nand2_1
X$7697 VDD VSS \$2958 \$2691 \$2712 sg13g2_nand2_1
X$7700 VSS \$2967 VDD \$2846 \$2958 \$2515 sg13g2_o21ai_1
X$7707 VDD VSS \$2960 \$2711 \$2712 sg13g2_nor2_1
X$7715 VDD VSS sg13g2_decap_4
X$7718 VSS VDD \$2926 \$2960 \$3030 \$2691 sg13g2_nand3_1
X$7725 VDD VSS sg13g2_decap_8
X$7734 VDD VSS sg13g2_decap_8
X$7739 VDD VSS \$2400 \$2828 sg13g2_inv_1
X$7740 VDD VSS sg13g2_decap_8
X$7748 \$2835 VSS \$2828 VDD \$2604 \$2751 sg13g2_a21oi_1
X$7754 VSS \$3035 VDD \$2515 \$2206 \$2400 sg13g2_o21ai_1
X$7755 VSS \$3041 VDD \$2604 \$3101 \$2515 sg13g2_o21ai_1
X$7757 VSS VDD \$3101 \$2400 \$2206 sg13g2_nor2b_1
X$7758 VDD VSS sg13g2_decap_8
X$7759 VDD VSS sg13g2_decap_8
X$7761 VDD VSS \$3212 \$2653 \$2399 \$2964 sg13g2_and3_1
X$7767 VSS \$2965 \$2901 \$2964 \$2456 VDD sg13g2_dfrbpq_1
X$7792 VDD VSS sg13g2_decap_8
X$7794 VDD VSS sg13g2_decap_8
X$7797 VDD VSS \$3057 \$2460 \$3045 sg13g2_nor2_1
X$7798 VSS \$2399 VDD \$2864 sg13g2_buf_1
X$7801 VDD VSS sg13g2_decap_8
X$7807 VDD VSS sg13g2_decap_8
X$7808 VDD VSS sg13g2_decap_8
X$7813 VSS \$2864 VDD \$1998 sg13g2_buf_1
X$7815 VDD VSS sg13g2_decap_8
X$7817 VDD VSS sg13g2_decap_8
X$7819 VDD VSS sg13g2_decap_8
X$7823 VDD VSS sg13g2_decap_8
X$7824 VDD VSS sg13g2_decap_8
X$7829 \$3048 VDD VSS sg13g2_tiehi
X$7834 VDD VSS sg13g2_decap_8
X$7838 VDD VSS sg13g2_decap_8
X$7839 VDD VSS sg13g2_decap_8
X$7840 VDD VSS sg13g2_decap_4
X$8116 VDD VSS sg13g2_decap_8
X$8118 \$2981 VDD VSS sg13g2_tiehi
X$8119 VSS \$2981 \$3197 \$3196 \$2105 VDD sg13g2_dfrbpq_1
X$8122 VDD VSS sg13g2_decap_8
X$8123 VDD VSS sg13g2_decap_8
X$8124 VDD VSS sg13g2_decap_8
X$8125 VDD VSS sg13g2_decap_8
X$8126 VDD VSS sg13g2_decap_8
X$8127 VDD VSS sg13g2_decap_8
X$8128 VDD VSS sg13g2_decap_8
X$8129 \$2985 VDD VSS sg13g2_tiehi
X$8130 VSS \$2985 \$3162 \$3234 \$2442 VDD sg13g2_dfrbpq_1
X$8139 VSS VDD \$3068 \$3499 \$3162 sg13g2_nor2b_1
X$8140 VDD VSS sg13g2_decap_8
X$8141 VDD VSS sg13g2_decap_4
X$8144 VSS \$3240 \$2984 \$3241 \$2840 VDD sg13g2_mux2_1
X$8145 VSS \$3165 \$3166 \$3240 \$2442 VDD sg13g2_dfrbpq_1
X$8146 VSS VDD \$3241 \$3499 \$3166 sg13g2_nor2b_1
X$8147 VDD VSS sg13g2_decap_8
X$8148 VDD VSS sg13g2_decap_8
X$8149 VDD VSS sg13g2_decap_8
X$8150 VDD VSS sg13g2_decap_8
X$8152 VSS VDD \$3198 \$2842 \$2989 \$2941 sg13g2_nand3_1
X$8155 VSS VDD \$3053 \$3167 \$3200 \$3168 sg13g2_nand3_1
X$8156 VDD VSS \$3167 \$1978 \$2996 sg13g2_nand2_1
X$8158 VDD VSS sg13g2_decap_8
X$8160 \$2994 VDD VSS sg13g2_tiehi
X$8161 VDD VSS sg13g2_decap_8
X$8162 VDD VSS sg13g2_decap_8
X$8164 VDD VSS sg13g2_decap_8
X$8165 VDD VSS sg13g2_decap_8
X$8166 VDD VSS sg13g2_decap_8
X$8172 VDD VSS sg13g2_decap_8
X$8173 VDD VSS sg13g2_decap_8
X$8176 \$2998 VDD VSS sg13g2_tiehi
X$8177 VSS \$2998 \$3001 \$3260 \$3174 VDD sg13g2_dfrbpq_1
X$8179 VDD VSS sg13g2_decap_8
X$8180 VDD VSS sg13g2_decap_8
X$8181 VDD VSS sg13g2_decap_8
X$8182 VDD VSS sg13g2_decap_8
X$8183 VDD VSS \$2989 \$3004 \$3175 sg13g2_nand2_1
X$8185 VDD VSS \$2945 \$3004 \$3266 sg13g2_nand2_1
X$8187 VDD VSS sg13g2_decap_8
X$8188 VDD VSS sg13g2_decap_8
X$8192 VSS VDD \$3004 \$2751 \$2691 sg13g2_nor2b_1
X$8194 VDD VSS \$2948 \$2829 \$3001 \$2694 sg13g2_nand3b_1
X$8196 VDD VSS sg13g2_decap_4
X$8198 VDD VSS \$2510 \$2694 \$3206 sg13g2_nand2b_1
X$8199 VDD VSS sg13g2_decap_8
X$8203 VDD VSS sg13g2_decap_8
X$8205 VDD VSS sg13g2_decap_4
X$8206 VDD VSS \$3012 \$2694 \$3020 sg13g2_nor2_1
X$8209 VDD VSS sg13g2_decap_8
X$8211 VDD VSS sg13g2_decap_8
X$8217 VDD VSS sg13g2_decap_8
X$8218 VDD VSS sg13g2_decap_8
X$8219 VDD VSS sg13g2_decap_8
X$8221 VDD VSS sg13g2_decap_8
X$8224 VDD VSS sg13g2_decap_8
X$8227 VDD VSS sg13g2_decap_8
X$8229 VDD VSS sg13g2_decap_8
X$8232 VDD VSS sg13g2_decap_4
X$8234 VDD VSS \$2711 \$2920 \$3030 sg13g2_nor2_1
X$8237 VSS \$2511 VDD \$3020 \$3030 \$2510 sg13g2_o21ai_1
X$8241 VDD VSS sg13g2_decap_8
X$8242 VSS \$2920 VDD \$2826 sg13g2_buf_1
X$8243 VDD VSS sg13g2_decap_8
X$8244 VDD VSS sg13g2_decap_8
X$8245 VDD VSS sg13g2_decap_8
X$8248 \$3293 VSS \$3035 VDD \$3041 \$2827 sg13g2_a21oi_1
X$8250 VSS \$3126 VDD \$3217 \$3216 \$2400 sg13g2_o21ai_1
X$8254 VDD VSS sg13g2_decap_8
X$8257 VDD VSS sg13g2_decap_8
X$8258 VDD VSS sg13g2_decap_8
X$8261 \$3184 VDD VSS sg13g2_tiehi
X$8262 VSS \$3184 \$3220 \$2963 \$2456 VDD sg13g2_dfrbpq_1
X$8269 VSS \$3317 VDD \$2460 sg13g2_buf_1
X$8270 VDD VSS sg13g2_decap_8
X$8271 VDD VSS sg13g2_decap_4
X$8272 \$3221 VDD VSS sg13g2_tiehi
X$8273 VSS \$3221 \$3222 \$3045 \$2292 VDD sg13g2_dfrbpq_1
X$8275 VDD VSS \$3222 \$2864 \$3182 sg13g2_nand2b_1
X$8278 \$2868 VSS \$3182 VDD \$3259 \$2460 sg13g2_a21oi_1
X$8279 VDD VSS sg13g2_decap_8
X$8280 VDD VSS sg13g2_decap_8
X$8281 VDD VSS \$3238 \$3181 \$2864 sg13g2_nand2_1
X$8282 VDD VSS sg13g2_decap_4
X$8283 \$3047 VSS \$397 VDD \$3238 \$3317 sg13g2_a21oi_1
X$8284 VSS \$3048 \$3226 \$3047 \$2292 VDD sg13g2_dfrbpq_1
X$8286 VDD VSS sg13g2_decap_4
X$8288 VDD VSS sg13g2_decap_8
X$8289 VDD VSS sg13g2_decap_8
X$8291 VDD VSS sg13g2_decap_8
X$8295 VDD VSS sg13g2_decap_8
X$8301 VDD VSS sg13g2_decap_8
X$8302 VDD VSS sg13g2_decap_8
X$8305 VDD VSS sg13g2_decap_8
X$8307 VDD VSS sg13g2_decap_4
X$8309 \$3320 VDD VSS sg13g2_tiehi
X$8310 VSS \$3320 \$3346 \$3295 \$3297 VDD sg13g2_dfrbpq_1
X$8312 VDD VSS sg13g2_decap_8
X$8314 VDD VSS sg13g2_decap_8
X$8322 \$3348 VDD VSS sg13g2_tiehi
X$8323 VDD VSS sg13g2_decap_8
X$8326 VDD VSS sg13g2_decap_8
X$8328 VDD VSS sg13g2_decap_8
X$8332 VDD VSS sg13g2_decap_8
X$8333 VDD VSS sg13g2_decap_8
X$8337 VDD VSS sg13g2_decap_4
X$8344 \$3165 VDD VSS sg13g2_tiehi
X$8347 VDD VSS sg13g2_decap_8
X$8349 VDD VSS sg13g2_decap_8
X$8354 VDD VSS sg13g2_decap_8
X$8356 \$3351 VDD VSS sg13g2_tiehi
X$8359 VDD VSS sg13g2_decap_8
X$8366 VDD VSS sg13g2_decap_8
X$8367 VDD VSS sg13g2_decap_8
X$8368 VDD VSS sg13g2_decap_8
X$8370 VDD VSS sg13g2_decap_8
X$8383 VDD VSS \$3252 \$1978 \$2990 sg13g2_nand2_1
X$8388 \$3352 VSS \$3252 VDD \$3200 \$2988 sg13g2_a21oi_1
X$8394 VSS \$2994 \$1978 \$3352 \$3174 VDD sg13g2_dfrbpq_1
X$8397 VDD VSS sg13g2_decap_8
X$8404 VDD VSS sg13g2_decap_8
X$8406 VDD VSS sg13g2_decap_8
X$8409 VDD VSS sg13g2_decap_8
X$8410 VDD VSS sg13g2_decap_8
X$8411 VDD VSS sg13g2_decap_4
X$8415 \$3353 VSS \$3301 VDD \$3302 \$2988 sg13g2_a21oi_1
X$8418 VDD VSS \$3301 \$3181 \$2990 sg13g2_nand2_1
X$8420 VDD VSS sg13g2_decap_4
X$8424 VDD VSS \$3203 \$3181 \$2996 sg13g2_nand2_1
X$8427 VSS VDD \$3356 \$3302 \$3203 \$2652 sg13g2_nand3_1
X$8428 VDD VSS sg13g2_decap_8
X$8432 VDD VSS sg13g2_decap_8
X$8433 VDD VSS sg13g2_decap_8
X$8435 VDD VSS \$3302 \$3004 \$3740 sg13g2_nand2_1
X$8440 VDD VSS sg13g2_decap_4
X$8442 VDD VSS \$3200 \$3358 \$3004 sg13g2_nand2_1
X$8449 VDD VSS sg13g2_decap_8
X$8458 VDD VSS sg13g2_decap_4
X$8461 VSS \$1620 CLK VDD sg13g2_buf_16
X$8476 VDD \$2694 VSS \$3630 \$2827 \$3305 \$3442 sg13g2_nand4_1
X$8482 VDD VSS \$3305 \$2828 \$3012 sg13g2_nand2_1
X$8483 VDD VSS sg13g2_decap_8
X$8491 VDD VSS sg13g2_decap_4
X$8492 VDD VSS \$3364 \$2694 \$3012 sg13g2_and2_1
X$8500 VSS \$3365 VDD \$2920 \$2510 sg13g2_xor2_1
X$8503 VDD VSS \$2920 \$2828 \$3368 sg13g2_nor2_1
X$8504 VDD VSS sg13g2_decap_8
X$8506 VDD VSS sg13g2_decap_8
X$8507 VDD VSS sg13g2_decap_8
X$8510 VDD VSS sg13g2_decap_8
X$8511 VDD VSS sg13g2_decap_4
X$8514 \$3372 VSS \$3309 VDD \$3373 \$2279 sg13g2_a21oi_1
X$8515 VDD VSS \$3309 \$1688 \$3212 sg13g2_nand2_1
X$8516 VDD VSS sg13g2_decap_8
X$8520 \$3411 VSS \$2967 VDD \$3217 \$2920 sg13g2_a21oi_1
X$8522 VDD VSS sg13g2_decap_8
X$8533 VDD VSS sg13g2_decap_4
X$8535 \$3377 VDD VSS sg13g2_tiehi
X$8538 VDD VSS sg13g2_decap_8
X$8544 VDD VSS sg13g2_decap_8
X$8546 VDD VSS sg13g2_decap_8
X$8549 VDD VSS sg13g2_decap_4
X$8551 VSS \$3658 VDD \$2769 \$3020 \$2828 sg13g2_o21ai_1
X$8559 \$3216 VSS \$3330 VDD \$2711 \$2827 sg13g2_a21oi_1
X$8567 VDD VSS sg13g2_decap_8
X$8569 VDD VSS sg13g2_decap_8
X$8572 VDD VSS \$3314 \$2604 \$3330 sg13g2_nor2_1
X$8573 VDD VSS sg13g2_decap_8
X$8576 VDD VSS sg13g2_decap_8
X$8580 VDD VSS sg13g2_decap_8
X$8582 VDD VSS sg13g2_decap_8
X$8583 VDD VSS sg13g2_decap_8
X$8587 VDD VSS sg13g2_decap_8
X$8589 VDD VSS sg13g2_decap_8
X$8590 VDD VSS sg13g2_decap_8
X$8594 VDD VSS sg13g2_decap_8
X$8596 VDD VSS sg13g2_decap_4
X$8599 VDD VSS \$3259 \$3382 \$2864 sg13g2_nand2_1
X$8601 \$3460 VDD VSS sg13g2_tiehi
X$8602 VDD VSS \$2869 \$2864 \$3315 sg13g2_nand2_1
X$8606 VDD VSS sg13g2_decap_8
X$8611 VDD VSS sg13g2_decap_8
X$8619 VDD VSS sg13g2_decap_8
X$8623 VDD VSS sg13g2_decap_4
X$8625 VDD VSS \$2864 \$3181 \$3392 sg13g2_nand2b_1
X$8631 VDD VSS sg13g2_decap_4
X$8634 \$3225 VSS \$3318 VDD \$3392 \$3317 sg13g2_a21oi_1
X$8639 VDD VSS \$3226 \$1998 \$3318 sg13g2_nand2b_1
X$8642 VDD VSS sg13g2_decap_8
X$8643 VDD VSS sg13g2_decap_8
X$8645 VDD VSS sg13g2_decap_8
X$8648 VDD VSS sg13g2_decap_4
X$8650 VDD VSS sg13g2_decap_8
X$8651 VDD VSS sg13g2_decap_8
X$8652 VDD VSS sg13g2_decap_8
X$8653 VDD VSS sg13g2_decap_8
X$8657 VDD VSS sg13g2_decap_8
X$8658 VDD VSS sg13g2_decap_8
X$8659 VDD VSS sg13g2_decap_8
X$8662 VSS \$3295 \$3437 \$3347 \$3053 VDD sg13g2_mux2_1
X$8667 VSS VDD \$3347 \$3542 \$3346 sg13g2_nor2b_1
X$8671 VDD VSS sg13g2_decap_8
X$8673 VDD VSS sg13g2_decap_8
X$8674 VDD VSS sg13g2_decap_8
X$8677 VDD VSS sg13g2_decap_8
X$8678 VDD VSS sg13g2_decap_4
X$8680 VSS \$3348 \$3495 \$3438 \$3439 VDD sg13g2_dfrbpq_1
X$8684 VDD VSS sg13g2_decap_8
X$8685 VDD VSS sg13g2_decap_8
X$8686 VDD VSS sg13g2_decap_8
X$8687 VDD VSS sg13g2_decap_8
X$8689 VDD VSS sg13g2_decap_4
X$8691 VSS \$3350 \$3437 \$3404 \$2840 VDD sg13g2_mux2_1
X$8692 VSS \$3351 \$3440 \$3350 \$3439 VDD sg13g2_dfrbpq_1
X$8697 VSS VDD \$3404 \$3499 \$3440 sg13g2_nor2b_1
X$8698 VDD VSS sg13g2_decap_8
X$8699 VDD VSS sg13g2_decap_8
X$8701 VDD VSS sg13g2_decap_8
X$8710 VDD VSS sg13g2_decap_8
X$8717 VDD VSS sg13g2_decap_8
X$8719 VDD VSS sg13g2_decap_8
X$8721 VDD VSS sg13g2_decap_8
X$8722 VDD VSS sg13g2_decap_8
X$8725 VDD VSS sg13g2_decap_8
X$8729 \$3409 VDD VSS sg13g2_tiehi
X$8730 VDD VSS sg13g2_decap_8
X$8731 VDD VSS sg13g2_decap_8
X$8732 VSS \$3409 \$3181 \$3353 \$3174 VDD sg13g2_dfrbpq_1
X$8750 VDD VSS sg13g2_decap_8
X$8755 VDD VSS sg13g2_decap_8
X$8756 VDD VSS sg13g2_decap_8
X$8757 VDD VSS sg13g2_decap_8
X$8759 VDD VSS sg13g2_decap_8
X$8767 VDD VSS sg13g2_decap_8
X$8771 VDD VSS sg13g2_decap_8
X$8772 VDD VSS sg13g2_decap_4
X$8773 VDD VSS \$3206 \$2751 \$3623 sg13g2_nor2_1
X$8776 VDD VSS sg13g2_decap_4
X$8778 VDD VSS \$3442 \$2510 \$2829 sg13g2_nand2_1
X$8781 VSS \$3536 VDD \$3442 \$3020 \$2826 sg13g2_o21ai_1
X$8783 VDD VSS sg13g2_decap_8
X$8796 VDD VSS sg13g2_decap_4
X$8803 VSS \$3445 VDD \$3367 \$3206 \$2827 sg13g2_o21ai_1
X$8806 VDD VSS sg13g2_decap_8
X$8808 VSS \$3365 VDD \$3534 \$3364 \$3444 \$2829 \$3445 sg13g2_a221oi_1
X$8814 VSS \$3444 VDD \$2653 \$3368 \$3367 sg13g2_o21ai_1
X$8820 VDD VSS sg13g2_decap_8
X$8825 VDD VSS sg13g2_decap_8
X$8826 VDD VSS sg13g2_decap_8
X$8827 VDD VSS sg13g2_decap_8
X$8833 VDD VSS \$3374 \$3528 \$3421 \$2279 sg13g2_nor3_1
X$8836 VDD VSS \$3501 \$1688 \$3421 sg13g2_nor2_1
X$8842 \$3374 VSS \$3502 VDD \$3217 \$2913 sg13g2_a21oi_1
X$8848 VDD VSS sg13g2_decap_8
X$8849 VDD VSS sg13g2_decap_8
X$8857 VDD VSS sg13g2_decap_4
X$8859 VSS \$3474 VDD \$2653 \$3467 \$3411 sg13g2_o21ai_1
X$8861 VSS \$3377 \$2826 \$3474 \$3450 VDD sg13g2_dfrbpq_1
X$8866 VDD VSS \$3467 \$3217 \$3293 sg13g2_and2_1
X$8870 VDD VSS sg13g2_decap_4
X$8878 VSS \$3217 VDD \$2283 sg13g2_buf_1
X$8883 VDD VSS sg13g2_decap_8
X$8886 VDD VSS sg13g2_decap_8
X$8887 VDD VSS sg13g2_decap_4
X$8888 \$2768 VSS \$3506 VDD \$3401 \$3315 sg13g2_a21oi_1
X$8893 VDD VSS sg13g2_decap_4
X$8894 VDD VSS \$3401 \$3382 \$3220 sg13g2_nand2_1
X$8895 VDD VSS sg13g2_decap_8
X$8896 VDD VSS sg13g2_decap_8
X$8898 VDD VSS sg13g2_decap_8
X$8899 VDD VSS sg13g2_decap_8
X$8900 VDD VSS sg13g2_decap_8
X$8901 VDD VSS sg13g2_decap_8
X$8902 VDD VSS sg13g2_decap_8
X$8903 VDD VSS sg13g2_decap_4
X$8905 VDD VSS \$2653 \$3458 \$1543 \$3463 sg13g2_and3_1
X$8908 VSS \$3460 \$3760 \$3463 \$3648 VDD sg13g2_dfrbpq_1
X$8919 VDD VSS sg13g2_decap_8
X$8923 VDD VSS sg13g2_decap_8
X$8933 \$3383 VDD VSS sg13g2_tiehi
X$8938 VSS \$3383 \$3455 \$1987 \$3648 VDD sg13g2_dfrbpq_1
X$8947 VSS SCAN_VALID VDD \$3455 sg13g2_buf_1
X$8949 VDD VSS sg13g2_decap_8
X$8950 \$3539 VDD VSS sg13g2_tiehi
X$8951 VSS \$3539 \$3541 \$3567 \$3297 VDD sg13g2_dfrbpq_1
X$8954 VSS \$3567 \$3525 \$3570 \$3053 VDD sg13g2_mux2_1
X$8956 VSS VDD \$3570 \$3542 \$3541 sg13g2_nor2b_1
X$8961 VSS \$3542 VDD \$2936 sg13g2_buf_1
X$8964 VDD VSS sg13g2_decap_8
X$8969 VDD VSS sg13g2_decap_8
X$8973 VDD VSS sg13g2_decap_8
X$8974 VDD VSS sg13g2_decap_8
X$8975 VDD VSS sg13g2_decap_8
X$8976 VSS \$3438 \$3437 \$3578 \$2944 VDD sg13g2_mux2_1
X$8980 VDD VSS sg13g2_decap_4
X$8987 VSS VDD \$3799 \$3542 \$3543 sg13g2_nor2b_1
X$8988 VDD VSS sg13g2_decap_8
X$8990 VSS VDD \$3578 \$3499 \$3495 sg13g2_nor2b_1
X$8992 VDD VSS sg13g2_decap_8
X$8994 VDD VSS sg13g2_decap_8
X$8996 VSS \$3548 \$3525 \$3663 \$2840 VDD sg13g2_mux2_1
X$8997 \$3549 VDD VSS sg13g2_tiehi
X$8998 VDD VSS sg13g2_decap_8
X$8999 VDD VSS sg13g2_decap_8
X$9005 VDD VSS sg13g2_decap_8
X$9008 VDD VSS sg13g2_decap_8
X$9010 VDD VSS sg13g2_decap_8
X$9015 VDD VSS sg13g2_decap_4
X$9016 VSS VDD \$3612 \$3499 \$3611 sg13g2_nor2b_1
X$9020 VDD VSS sg13g2_decap_4
X$9024 \$3714 VDD VSS sg13g2_tiehi
X$9025 VDD VSS sg13g2_decap_4
X$9027 VSS \$3499 VDD \$3542 sg13g2_buf_1
X$9029 VDD VSS sg13g2_decap_8
X$9030 VDD VSS sg13g2_decap_8
X$9032 VDD VSS sg13g2_decap_8
X$9034 \$3593 VDD VSS sg13g2_tiehi
X$9035 VSS \$3593 \$3683 \$3673 \$3174 VDD sg13g2_dfrbpq_1
X$9040 VDD VSS sg13g2_decap_8
X$9043 VDD VSS sg13g2_decap_8
X$9044 VDD VSS sg13g2_decap_8
X$9048 \$3553 VDD VSS sg13g2_tiehi
X$9050 VDD VSS sg13g2_decap_8
X$9052 VDD VSS sg13g2_decap_8
X$9053 VDD VSS sg13g2_decap_8
X$9055 VDD VSS sg13g2_decap_8
X$9056 VDD VSS sg13g2_decap_8
X$9057 VDD VSS sg13g2_decap_8
X$9058 VDD VSS sg13g2_decap_8
X$9062 VDD VSS sg13g2_decap_8
X$9064 VDD VSS sg13g2_decap_8
X$9065 VDD VSS sg13g2_decap_8
X$9066 VDD VSS sg13g2_decap_8
X$9073 VDD VSS \$3536 \$3730 sg13g2_inv_1
X$9077 VDD VSS sg13g2_decap_8
X$9088 VDD VSS sg13g2_decap_8
X$9092 VDD VSS sg13g2_decap_4
X$9094 VSS \$3555 \$3367 \$3534 \$3556 VDD sg13g2_dfrbpq_1
X$9127 VDD VSS sg13g2_decap_8
X$9129 VDD VSS sg13g2_decap_8
X$9131 VDD VSS sg13g2_decap_8
X$9134 \$3594 VDD VSS sg13g2_tiehi
X$9135 VSS \$3594 \$2913 \$3528 \$3450 VDD sg13g2_dfrbpq_1
X$9156 VDD VSS sg13g2_decap_8
X$9159 VDD VSS sg13g2_decap_8
X$9167 VDD VSS sg13g2_decap_8
X$9170 VDD VSS sg13g2_decap_8
X$9174 VDD VSS sg13g2_decap_8
X$9176 VDD VSS \$2767 \$3557 \$3588 \$3293 sg13g2_nand3b_1
X$9184 VDD VSS sg13g2_decap_8
X$9187 VDD VSS sg13g2_decap_8
X$9192 VDD VSS sg13g2_decap_8
X$9193 VDD VSS sg13g2_decap_8
X$9196 VDD VSS \$3506 \$3639 \$3558 sg13g2_nand2_1
X$9201 VDD VSS sg13g2_decap_8
X$9208 VDD VSS sg13g2_decap_8
X$9215 VDD VSS \$3220 \$3382 \$3515 sg13g2_nand2b_1
X$9218 VDD VSS sg13g2_decap_8
X$9224 VSS \$2711 VDD \$3562 \$3515 \$3558 sg13g2_o21ai_1
X$9225 VDD VSS \$3562 \$3315 \$3220 sg13g2_nand2_1
X$9227 VDD VSS sg13g2_decap_8
X$9228 VDD VSS sg13g2_decap_8
X$9229 VDD VSS sg13g2_decap_8
X$9230 VDD VSS sg13g2_decap_8
X$9234 VDD VSS sg13g2_decap_8
X$9239 VDD VSS sg13g2_decap_4
X$9242 VSS \$3458 VDD \$3647 \$3760 sg13g2_xor2_1
X$9245 VDD VSS sg13g2_decap_8
X$9246 VDD VSS sg13g2_decap_8
X$9250 VDD VSS sg13g2_decap_8
X$9251 VDD VSS sg13g2_decap_8
X$9252 VDD VSS sg13g2_decap_8
X$9256 VDD VSS sg13g2_decap_8
X$9258 VDD VSS sg13g2_decap_8
X$9260 VDD VSS sg13g2_decap_8
X$9261 VDD VSS sg13g2_decap_8
X$9267 VDD VSS sg13g2_decap_8
X$9268 VDD VSS sg13g2_decap_8
X$9272 VDD VSS sg13g2_decap_8
X$9274 VDD VSS sg13g2_decap_8
X$9279 VDD VSS sg13g2_decap_8
X$9280 VDD VSS sg13g2_decap_8
X$9284 VDD VSS sg13g2_decap_8
X$9290 VSS VDD \$3930 \$2936 \$3603 sg13g2_nor2b_1
X$9296 VSS \$3870 \$3797 \$3676 \$3541 \$3346 \$3197 \$3603 VDD sg13g2_mux4_1
X$9301 VDD VSS sg13g2_decap_8
X$9304 \$3705 VDD VSS sg13g2_tiehi
X$9305 VSS \$3705 \$3543 \$3704 \$3439 VDD sg13g2_dfrbpq_1
X$9319 VSS \$3870 \$3769 \$3676 \$3679 \$3495 \$3162 \$3543 VDD sg13g2_mux4_1
X$9327 VDD VSS sg13g2_decap_4
X$9329 VSS VDD \$3663 \$3499 \$3607 sg13g2_nor2b_1
X$9334 VSS \$3549 \$3607 \$3548 \$3439 VDD sg13g2_dfrbpq_1
X$9338 VDD VSS sg13g2_decap_4
X$9340 VSS \$3774 \$3872 \$3676 \$3607 \$3440 \$3166 \$3611 VDD sg13g2_mux4_1
X$9348 VSS \$3714 \$3611 \$3682 \$3174 VDD sg13g2_dfrbpq_1
X$9356 VDD VSS sg13g2_decap_8
X$9358 VSS \$3673 \$3437 \$3778 \$2992 VDD sg13g2_mux2_1
X$9364 VDD VSS sg13g2_decap_4
X$9368 VSS VDD \$3778 \$2988 \$3683 sg13g2_nor2b_1
X$9371 \$3616 VDD VSS sg13g2_tiehi
X$9372 VSS \$3616 \$4039 \$3617 \$3174 VDD sg13g2_dfrbpq_1
X$9375 VSS \$3553 \$3875 \$3617 \$3174 VDD sg13g2_dfrbpq_1
X$9377 VDD VSS sg13g2_decap_4
X$9378 VDD VSS \$3738 \$2988 \$3617 sg13g2_nor2_1
X$9380 \$3738 VSS VDD \$3619 \$3875 \$3618 \$3536 sg13g2_a22oi_1
X$9381 VDD VSS \$3619 \$3739 \$3623 \$3740 sg13g2_a21o_1
X$9382 VSS \$3618 VDD \$3536 \$3741 \$3620 sg13g2_o21ai_1
X$9386 VDD VSS \$3802 \$3742 \$3623 \$3358 sg13g2_a21o_1
X$9388 VDD VSS \$3630 \$3623 \$3741 sg13g2_nand2b_1
X$9389 VDD VSS sg13g2_decap_4
X$9391 VDD VSS \$3689 \$3623 \$3266 sg13g2_nand2_1
X$9392 VSS \$3627 VDD \$3689 \$3623 \$3620 sg13g2_o21ai_1
X$9393 \$3789 VSS \$3730 VDD \$3620 \$3627 sg13g2_a21oi_1
X$9396 VSS \$3744 VDD \$2653 \$3536 \$3620 sg13g2_o21ai_1
X$9397 \$4059 VSS \$3789 VDD \$3630 \$3744 sg13g2_a21oi_1
X$9398 VDD VSS sg13g2_decap_8
X$9399 VDD VSS sg13g2_decap_4
X$9402 \$3555 VDD VSS sg13g2_tiehi
X$9404 VDD VSS sg13g2_decap_8
X$9405 VDD VSS sg13g2_decap_8
X$9407 VDD VSS sg13g2_decap_8
X$9410 VDD VSS sg13g2_decap_8
X$9411 VDD VSS sg13g2_decap_8
X$9412 VDD VSS sg13g2_decap_4
X$9414 VSS \$3632 VDD \$3745 \$2851 \$2751 sg13g2_o21ai_1
X$9415 VDD VSS sg13g2_decap_8
X$9419 VDD VSS sg13g2_decap_4
X$9423 VSS VDD \$3373 \$3736 \$3664 \$3217 sg13g2_nand3_1
X$9427 VDD VSS \$3691 \$3502 sg13g2_inv_1
X$9429 \$3664 VSS \$3776 VDD \$3212 \$3632 sg13g2_a21oi_1
X$9430 VDD VSS sg13g2_decap_8
X$9433 VDD VSS sg13g2_decap_8
X$9434 VDD VSS sg13g2_decap_8
X$9435 VDD VSS sg13g2_decap_4
X$9440 VDD VSS \$2913 \$3637 sg13g2_inv_1
X$9441 VSS \$3746 VDD \$3637 \$3558 \$3212 sg13g2_o21ai_1
X$9444 VSS \$3557 VDD \$3212 \$3813 \$3632 sg13g2_o21ai_1
X$9445 VDD VSS \$3212 \$3748 sg13g2_inv_1
X$9450 VDD VSS sg13g2_decap_4
X$9453 VDD VSS \$3967 \$3694 \$3695 \$3658 \$3588 sg13g2_nor4_1
X$9455 VDD VSS sg13g2_decap_4
X$9457 \$3695 VSS VDD \$3696 \$3641 \$3750 \$3639 sg13g2_a22oi_1
X$9458 VDD VSS sg13g2_decap_4
X$9460 VDD VSS \$3315 \$3696 sg13g2_inv_1
X$9461 VDD VSS \$3382 \$3639 sg13g2_inv_1
X$9467 VDD VSS \$3558 \$3382 \$3640 sg13g2_nor2_1
X$9468 VDD VSS \$2835 \$3754 \$3641 \$3640 sg13g2_nor3_1
X$9469 VDD VSS \$3644 \$3315 \$3641 sg13g2_nand2b_1
X$9470 VDD VSS sg13g2_decap_8
X$9477 VSS \$3644 VDD \$3220 sg13g2_buf_1
X$9478 VDD VSS sg13g2_decap_8
X$9484 VDD VSS sg13g2_decap_8
X$9490 VSS \$3314 VDD \$2206 sg13g2_buf_1
X$9491 VDD VSS sg13g2_decap_8
X$9492 VDD VSS sg13g2_decap_8
X$9493 VDD VSS sg13g2_decap_8
X$9494 VDD VSS sg13g2_decap_4
X$9496 VDD VSS \$3822 \$3646 sg13g2_inv_1
X$9497 VDD VSS \$3761 \$3646 \$3647 sg13g2_nor2_1
X$9499 VDD VSS sg13g2_decap_8
X$9502 VDD VSS sg13g2_decap_8
X$9503 VDD VSS sg13g2_decap_4
X$9504 VSS \$3648 VDD sg13g2_buf_8
X$9510 \$3829 VSS \$3763 VDD \$3701 \$3317 sg13g2_a21oi_1
X$9511 VDD VSS sg13g2_decap_4
X$9513 \$3650 VDD VSS sg13g2_tiehi
X$9514 VDD VSS sg13g2_decap_8
X$9515 VDD VSS sg13g2_decap_8
X$9516 VDD VSS sg13g2_decap_4
X$9751 VDD VSS sg13g2_decap_4
X$9753 \$3921 VDD VSS sg13g2_tiehi
X$9754 VSS \$3921 \$3867 \$3920 \$3297 VDD sg13g2_dfrbpq_1
X$9760 \$2936 \$3920 \$3867 VDD VSS sg13g2_or2_1
X$9761 VDD VSS sg13g2_decap_4
X$9762 VSS \$3929 \$3795 \$3930 \$3053 VDD sg13g2_mux2_1
X$9764 VSS \$3868 \$3603 \$3929 \$3297 VDD sg13g2_dfrbpq_1
X$9768 VDD VSS sg13g2_decap_8
X$9771 VDD VSS sg13g2_decap_8
X$9772 VSS \$3704 \$3795 \$3799 \$2944 VDD sg13g2_mux2_1
X$9774 VDD VSS sg13g2_decap_8
X$9775 VDD VSS sg13g2_decap_8
X$9777 VDD VSS sg13g2_decap_8
X$9778 VDD VSS sg13g2_decap_8
X$9779 VDD VSS sg13g2_decap_8
X$9783 VDD VSS sg13g2_decap_8
X$9784 VDD VSS sg13g2_decap_8
X$9785 VDD VSS sg13g2_decap_8
X$9786 VDD VSS sg13g2_decap_8
X$9787 VDD VSS sg13g2_decap_8
X$9788 VDD VSS sg13g2_decap_8
X$9790 VDD VSS sg13g2_decap_8
X$9797 VSS \$3682 \$3795 \$3612 \$2840 VDD sg13g2_mux2_1
X$9800 VDD VSS sg13g2_decap_8
X$9802 VDD VSS sg13g2_decap_8
X$9803 VDD VSS sg13g2_decap_8
X$9804 VDD VSS sg13g2_decap_8
X$9805 VDD VSS sg13g2_decap_8
X$9806 VDD VSS sg13g2_decap_8
X$9809 VDD VSS sg13g2_decap_8
X$9810 VDD VSS sg13g2_decap_8
X$9814 VDD VSS sg13g2_decap_8
X$9817 VSS \$3174 \$4566 VDD sg13g2_buf_16
X$9821 VDD VSS sg13g2_decap_8
X$9822 VDD VSS sg13g2_decap_8
X$9823 VDD VSS sg13g2_decap_8
X$9825 VDD VSS sg13g2_decap_8
X$9827 VDD VSS sg13g2_decap_8
X$9829 VDD VSS sg13g2_decap_4
X$9834 VSS VDD \$3739 \$3741 \$3874 sg13g2_nor2b_1
X$9838 VDD VSS \$3801 \$3620 \$3875 sg13g2_nand2_1
X$9849 VDD VSS \$3801 \$3742 \$3741 \$3879 sg13g2_nor3_1
X$9852 VDD VSS sg13g2_decap_8
X$9858 VDD VSS sg13g2_decap_8
X$9864 VSS \$3620 VDD \$3984 sg13g2_buf_1
X$9868 VDD VSS sg13g2_decap_8
X$9872 VDD VSS sg13g2_decap_8
X$9876 VDD VSS sg13g2_decap_8
X$9880 VDD VSS sg13g2_decap_8
X$9881 VDD VSS sg13g2_decap_8
X$9882 VDD VSS sg13g2_decap_8
X$9883 VDD VSS sg13g2_decap_4
X$9884 VSS VDD \$3883 \$3746 \$2953 \$3018 \$3745 sg13g2_and4_1
X$9885 VDD \$3745 VSS \$4323 \$3018 \$2953 \$3746 sg13g2_nand4_1
X$9886 VDD VSS sg13g2_decap_4
X$9887 VSS VDD \$4135 \$3632 \$3746 \$2653 sg13g2_nand3_1
X$9888 VDD VSS sg13g2_decap_8
X$9889 VDD VSS sg13g2_decap_8
X$9890 VDD VSS sg13g2_decap_4
X$9892 VDD VSS \$3746 \$3736 sg13g2_inv_1
X$9895 VDD VSS \$3691 \$3632 \$3736 sg13g2_nand2_1
X$9897 \$3501 VSS VDD \$3212 \$3691 \$3899 \$2913 sg13g2_a22oi_1
X$9903 VDD VSS sg13g2_decap_8
X$9907 VDD VSS sg13g2_decap_8
X$9910 VDD VSS sg13g2_decap_8
X$9911 VDD VSS sg13g2_decap_4
X$9913 VDD VSS \$3813 \$3637 \$3894 sg13g2_nand2_1
X$9919 VSS \$3450 VDD sg13g2_buf_8
X$9925 \$3967 VSS \$3750 VDD \$3748 \$3637 sg13g2_a21oi_1
X$9928 VDD VSS \$3897 \$2913 \$3748 sg13g2_nand2_1
X$9930 VDD VSS sg13g2_decap_8
X$9934 VDD VSS \$3847 \$3894 \$3750 sg13g2_nand2_1
X$9935 VDD VSS sg13g2_decap_8
X$9939 VDD VSS sg13g2_decap_4
X$9941 VSS \$3952 VDD \$2283 \$3899 \$3696 sg13g2_o21ai_1
X$9947 VDD VSS sg13g2_decap_8
X$9952 VDD VSS sg13g2_decap_4
X$9954 VSS \$3761 VDD \$2283 \$3847 \$3314 sg13g2_o21ai_1
X$9955 VDD VSS \$3212 \$2913 \$3841 \$3908 \$3694 sg13g2_nor4_1
X$9961 VDD VSS sg13g2_decap_8
X$9966 \$3903 VSS \$3952 VDD \$3382 \$3844 sg13g2_a21oi_1
X$9968 VDD VSS \$3904 \$3844 \$3644 \$3315 sg13g2_nor3_1
X$9970 \$3904 VSS \$3558 VDD \$2283 \$3382 sg13g2_a21oi_1
X$9972 VDD VSS sg13g2_decap_4
X$9974 VDD VSS \$3906 \$3841 sg13g2_inv_1
X$9976 VDD VSS sg13g2_decap_8
X$9978 VDD VSS sg13g2_decap_8
X$9980 VDD VSS sg13g2_decap_8
X$9983 VSS VDD \$3558 \$3906 \$3911 \$3760 \$3822 sg13g2_and4_1
X$9984 VSS VDD \$3908 \$3760 \$3911 \$3822 sg13g2_nand3_1
X$9985 VDD VSS sg13g2_decap_4
X$9987 VDD VSS \$3823 \$3822 \$3760 sg13g2_nand2_1
X$9988 VSS \$3648 \$4583 VDD sg13g2_buf_16
X$9999 VSS \$3650 \$3911 \$3829 \$3648 VDD sg13g2_dfrbpq_1
X$10136 VDD VSS sg13g2_decap_8
X$10137 VDD VSS sg13g2_decap_8
X$10140 VDD VSS sg13g2_decap_8
X$10143 VDD VSS sg13g2_decap_8
X$10144 VDD VSS sg13g2_decap_8
X$10145 VDD VSS sg13g2_decap_4
X$10149 VSS \$4074 \$3981 \$3053 \$3978 VDD sg13g2_mux2_1
X$10152 VDD VSS sg13g2_decap_4
X$10154 \$3868 VDD VSS sg13g2_tiehi
X$10155 VDD VSS sg13g2_decap_8
X$10157 VDD VSS sg13g2_decap_8
X$10159 VDD VSS sg13g2_decap_8
X$10160 VDD VSS sg13g2_decap_8
X$10161 VDD VSS sg13g2_decap_8
X$10162 VDD VSS sg13g2_decap_4
X$10163 VSS \$4023 \$3525 \$4035 \$2944 VDD sg13g2_mux2_1
X$10165 VSS VDD \$4035 \$3542 \$3679 sg13g2_nor2b_1
X$10166 VDD VSS sg13g2_decap_8
X$10167 VDD VSS sg13g2_decap_8
X$10168 VDD VSS sg13g2_decap_8
X$10170 VSS \$3870 VDD \$4039 sg13g2_buf_1
X$10171 VDD VSS sg13g2_decap_8
X$10173 VSS \$3439 \$3979 VDD sg13g2_buf_16
X$10174 VSS \$4103 \$3981 \$2840 \$3980 VDD sg13g2_mux2_1
X$10175 VDD VSS sg13g2_decap_8
X$10176 VDD VSS sg13g2_decap_8
X$10178 VDD VSS sg13g2_decap_8
X$10180 VDD VSS sg13g2_decap_8
X$10181 VDD VSS sg13g2_decap_8
X$10183 VSS \$2988 VDD \$3499 sg13g2_buf_1
X$10184 VDD VSS sg13g2_decap_4
X$10186 \$4229 VDD VSS sg13g2_tiehi
X$10187 VDD VSS sg13g2_decap_8
X$10189 VDD VSS sg13g2_decap_8
X$10190 VDD VSS sg13g2_decap_8
X$10191 VDD VSS sg13g2_decap_8
X$10192 VDD VSS sg13g2_decap_8
X$10194 VDD VSS sg13g2_decap_4
X$10197 VDD VSS \$3437 \$3874 \$3983 sg13g2_nand2_1
X$10199 VDD VSS \$3981 \$4045 \$3874 sg13g2_and2_1
X$10200 VDD VSS sg13g2_decap_8
X$10202 VDD VSS sg13g2_decap_8
X$10204 VSS VDD \$3874 \$3875 \$3984 sg13g2_nor2b_1
X$10205 VDD VSS sg13g2_decap_4
X$10207 VDD VSS \$3983 \$3879 \$3624 sg13g2_and2_1
X$10208 VDD VSS \$3795 \$3988 \$3983 sg13g2_nand2_1
X$10209 VDD VSS sg13g2_decap_4
X$10211 VDD VSS \$4056 \$2988 \$3989 sg13g2_nor2_1
X$10212 VDD VSS \$3988 \$3984 \$3875 sg13g2_and2_1
X$10213 VSS \$4024 VDD \$3536 \$3988 \$3741 sg13g2_o21ai_1
X$10218 \$4056 VSS VDD \$3802 \$3879 \$4024 \$3536 sg13g2_a22oi_1
X$10220 VDD VSS sg13g2_decap_8
X$10223 VDD VSS sg13g2_decap_8
X$10224 VDD VSS sg13g2_decap_8
X$10226 VDD VSS sg13g2_decap_8
X$10227 VDD VSS sg13g2_decap_8
X$10228 VDD VSS sg13g2_decap_8
X$10231 \$4171 VDD VSS sg13g2_tiehi
X$10232 VDD VSS sg13g2_decap_8
X$10233 VDD VSS sg13g2_decap_8
X$10234 VDD VSS sg13g2_decap_8
X$10236 \$3993 VDD VSS sg13g2_tiehi
X$10241 VSS \$3993 \$3745 \$4135 \$4170 VDD sg13g2_dfrbpq_1
X$10248 VDD VSS sg13g2_decap_8
X$10252 \$3994 VDD VSS sg13g2_tiehi
X$10255 VSS \$3994 \$3212 \$3372 \$3450 VDD sg13g2_dfrbpq_1
X$10261 VDD VSS sg13g2_decap_8
X$10262 VDD VSS sg13g2_decap_4
X$10265 VSS \$3450 \$765 VDD sg13g2_buf_16
X$10273 VDD VSS sg13g2_decap_8
X$10276 VSS \$4060 VDD \$2283 \$3899 \$3996 sg13g2_o21ai_1
X$10281 VSS \$4177 VDD \$3696 \$4019 \$4060 sg13g2_o21ai_1
X$10283 VSS VDD \$4062 \$3315 \$3899 \$2283 sg13g2_nand3_1
X$10286 \$4019 VSS \$3558 VDD \$3996 \$3382 sg13g2_a21oi_1
X$10293 VDD VSS sg13g2_decap_8
X$10295 VDD VSS sg13g2_decap_8
X$10299 VDD VSS sg13g2_decap_8
X$10303 VDD VSS sg13g2_decap_8
X$10305 VDD VSS sg13g2_decap_4
X$10310 VDD VSS \$3903 \$3317 \$4063 sg13g2_nor2_1
X$10314 VDD VSS sg13g2_decap_8
X$10317 VDD VSS sg13g2_decap_8
X$10319 VDD VSS sg13g2_decap_8
X$10321 VDD VSS sg13g2_decap_8
X$10323 VDD VSS sg13g2_decap_4
X$10325 VDD VSS \$3761 \$3910 \$3908 \$3906 sg13g2_nor3_1
X$10327 \$4066 VSS \$3908 VDD \$3906 \$3910 sg13g2_a21oi_1
X$10332 VDD VSS sg13g2_decap_8
X$10340 VDD VSS sg13g2_decap_8
X$10342 VDD VSS sg13g2_decap_4
X$10346 VDD VSS \$3314 \$3761 \$3911 \$3823 \$3763 sg13g2_or4_1
X$10350 \$4016 VSS \$3760 VDD \$3822 \$3314 sg13g2_a21oi_1
X$10352 VSS \$3701 VDD \$3911 \$4016 \$3761 sg13g2_o21ai_1
X$10354 \$4190 VDD VSS sg13g2_tiehi
X$10355 VDD VSS \$4076 \$3317 \$3916 sg13g2_nor2_1
X$10356 VDD VSS sg13g2_decap_8
X$10357 VDD VSS sg13g2_decap_8
X$10358 VDD VSS sg13g2_decap_8
X$10359 VDD VSS sg13g2_decap_4
X$10362 VDD VSS sg13g2_decap_8
X$10365 \$4144 VDD VSS sg13g2_tiehi
X$10366 VSS \$4144 \$4252 \$4074 \$3297 VDD sg13g2_dfrbpq_1
X$10370 VDD VSS sg13g2_decap_4
X$10377 VSS \$3297 \$3979 VDD sg13g2_buf_16
X$10387 VSS \$4034 VDD \$2936 sg13g2_buf_1
X$10388 VDD VSS sg13g2_decap_8
X$10389 VDD VSS sg13g2_decap_8
X$10390 VDD VSS sg13g2_decap_4
X$10392 \$4201 VDD VSS sg13g2_tiehi
X$10393 VSS \$4201 \$3679 \$4023 \$3439 VDD sg13g2_dfrbpq_1
X$10409 VDD VSS sg13g2_decap_4
X$10411 VSS \$4156 \$4041 \$2840 \$4151 VDD sg13g2_mux2_1
X$10416 \$4258 VDD VSS sg13g2_tiehi
X$10417 VDD VSS sg13g2_decap_8
X$10418 VDD VSS sg13g2_decap_8
X$10420 VDD VSS sg13g2_decap_8
X$10422 VDD VSS sg13g2_decap_4
X$10424 VSS VDD \$3980 \$4034 \$4107 sg13g2_nor2b_1
X$10428 \$4220 VDD VSS sg13g2_tiehi
X$10434 VSS \$4220 \$4107 \$4103 \$3439 VDD sg13g2_dfrbpq_1
X$10441 VDD VSS sg13g2_decap_8
X$10442 VDD VSS sg13g2_decap_8
X$10445 \$3499 \$4040 \$4161 VDD VSS sg13g2_or2_1
X$10447 VSS \$4229 \$4161 \$4040 \$3174 VDD sg13g2_dfrbpq_1
X$10450 VDD VSS sg13g2_decap_8
X$10451 VDD VSS sg13g2_decap_4
X$10457 VSS \$3774 VDD \$4039 sg13g2_buf_1
X$10462 VDD VSS \$4041 \$4045 \$4164 sg13g2_and2_1
X$10465 VDD VSS \$2984 \$4164 \$3983 sg13g2_nand2_1
X$10475 VDD VSS \$3525 \$3983 \$4238 sg13g2_nand2_1
X$10477 VDD VSS \$3875 \$3984 \$4238 sg13g2_nor2_1
X$10479 VSS VDD \$4164 \$3984 \$3875 sg13g2_nor2b_1
X$10482 VDD VSS sg13g2_decap_8
X$10485 VDD VSS sg13g2_decap_8
X$10493 VSS VDD \$4045 \$3879 \$3624 sg13g2_nor2b_1
X$10499 VDD VSS \$4371 \$3988 \$4045 sg13g2_and2_1
X$10505 VSS \$4247 \$3879 \$3989 \$4170 VDD sg13g2_dfrbpq_1
X$10536 \$4247 VDD VSS sg13g2_tiehi
X$10537 VDD VSS sg13g2_decap_8
X$10538 VDD VSS sg13g2_decap_8
X$10541 VDD VSS sg13g2_decap_8
X$10542 VDD VSS sg13g2_decap_4
X$10544 \$4299 VDD VSS sg13g2_tiehi
X$10546 VSS \$4171 \$3984 \$4059 \$4170 VDD sg13g2_dfrbpq_1
X$10548 VDD VSS sg13g2_decap_8
X$10549 VDD VSS sg13g2_decap_8
X$10558 VDD VSS sg13g2_decap_8
X$10559 VDD VSS sg13g2_decap_8
X$10562 VDD VSS sg13g2_decap_8
X$10564 VDD VSS sg13g2_decap_8
X$10565 VDD VSS sg13g2_decap_8
X$10568 VDD VSS sg13g2_decap_8
X$10573 VDD VSS sg13g2_decap_8
X$10576 VDD VSS sg13g2_decap_8
X$10577 \$4294 VDD VSS sg13g2_tiehi
X$10578 VDD VSS sg13g2_decap_8
X$10580 VDD VSS sg13g2_decap_8
X$10583 VDD VSS sg13g2_decap_8
X$10586 VDD VSS sg13g2_decap_8
X$10587 VDD VSS sg13g2_decap_8
X$10589 VDD VSS sg13g2_decap_8
X$10591 VDD VSS sg13g2_decap_8
X$10595 VDD VSS sg13g2_decap_8
X$10605 VDD VSS \$2653 \$4062 \$4177 \$4178 sg13g2_and3_1
X$10612 VDD VSS sg13g2_decap_8
X$10620 \$4217 VDD VSS sg13g2_tiehi
X$10621 VSS \$4217 \$3315 \$4178 \$3648 VDD sg13g2_dfrbpq_1
X$10630 VSS \$4179 \$3382 \$4063 \$4577 VDD sg13g2_dfrbpq_1
X$10635 VDD VSS sg13g2_decap_8
X$10636 VDD VSS sg13g2_decap_4
X$10640 VDD VSS \$4066 \$3314 \$4180 sg13g2_nor2_1
X$10648 \$4181 VSS \$3761 VDD \$3906 \$4180 sg13g2_a21oi_1
X$10654 VDD VSS sg13g2_decap_8
X$10656 VDD VSS sg13g2_decap_8
X$10657 VDD VSS sg13g2_decap_8
X$10669 VDD VSS \$3761 \$4069 \$3314 \$3822 sg13g2_nor3_1
X$10679 \$4076 VSS \$3761 VDD \$3822 \$4069 sg13g2_a21oi_1
X$10688 VSS \$4190 \$3822 \$3916 \$3648 VDD sg13g2_dfrbpq_1
X$10695 VDD VSS sg13g2_decap_8
X$10698 VDD VSS sg13g2_decap_8
X$10699 VDD VSS sg13g2_decap_8
X$10701 VDD VSS sg13g2_decap_8
X$10704 VDD VSS sg13g2_decap_8
X$10710 VDD VSS sg13g2_decap_8
X$10711 VDD VSS sg13g2_decap_8
X$10715 VSS VDD \$3978 \$2936 \$4252 sg13g2_nor2b_1
X$10716 VSS \$3870 \$4148 \$3676 \$3867 \$4252 \$4307 \$4254 VDD sg13g2_mux4_1
X$10722 VSS \$4203 \$4259 \$3797 \$4148 VDD sg13g2_mux2_1
X$10727 VDD VSS sg13g2_decap_8
X$10728 VDD VSS sg13g2_decap_8
X$10729 VDD VSS sg13g2_decap_8
X$10732 VDD VSS sg13g2_decap_8
X$10737 VDD VSS sg13g2_decap_8
X$10740 VDD VSS sg13g2_decap_8
X$10744 VDD VSS sg13g2_decap_8
X$10747 VDD VSS sg13g2_decap_8
X$10752 VSS VDD \$4151 \$4034 \$4260 sg13g2_nor2b_1
X$10761 VSS \$4258 \$4260 \$4156 \$3439 VDD sg13g2_dfrbpq_1
X$10768 VSS \$4039 \$4303 \$3676 \$2937 \$4107 \$4260 \$4262 VDD sg13g2_mux4_1
X$10787 VDD VSS sg13g2_decap_8
X$10791 VSS \$4226 \$4259 \$3872 \$4303 VDD sg13g2_mux2_1
X$10792 VDD VSS sg13g2_decap_8
X$10795 VDD VSS sg13g2_decap_8
X$10796 VDD VSS sg13g2_decap_8
X$10801 VDD VSS sg13g2_decap_8
X$10804 VDD VSS sg13g2_decap_4
X$10806 VSS \$4312 VDD \$3542 sg13g2_buf_1
X$10808 VDD VSS sg13g2_decap_8
X$10811 VDD VSS sg13g2_decap_8
X$10814 VDD VSS sg13g2_decap_8
X$10816 VDD VSS sg13g2_decap_8
X$10823 VDD VSS sg13g2_decap_8
X$10831 VDD VSS sg13g2_decap_8
X$10839 VDD VSS sg13g2_decap_8
X$10849 VDD VSS sg13g2_decap_8
X$10852 VDD VSS sg13g2_decap_8
X$10853 VDD VSS sg13g2_decap_8
X$10858 VDD VSS sg13g2_decap_8
X$10864 VDD VSS sg13g2_decap_8
X$10870 VDD VSS sg13g2_decap_8
X$10874 VDD VSS sg13g2_decap_8
X$10878 VDD VSS sg13g2_decap_8
X$10881 VDD VSS sg13g2_decap_8
X$10884 VDD VSS sg13g2_decap_8
X$10885 VDD VSS sg13g2_decap_8
X$10887 VDD VSS sg13g2_decap_8
X$10888 VSS \$4299 \$4386 \$4059 \$4170 VDD sg13g2_dfrbpq_1
X$10893 \$4321 VDD VSS sg13g2_tiehi
X$10894 VDD VSS sg13g2_decap_8
X$10897 VDD VSS sg13g2_decap_8
X$10899 VDD VSS sg13g2_decap_8
X$10900 VDD VSS sg13g2_decap_8
X$10901 VDD VSS sg13g2_decap_8
X$10902 VDD VSS sg13g2_decap_8
X$10903 VDD VSS sg13g2_decap_8
X$10904 VDD VSS sg13g2_decap_8
X$10905 VDD VSS sg13g2_decap_8
X$10906 VDD VSS sg13g2_decap_8
X$10909 VSS \$4294 \$4175 \$4341 \$3450 VDD sg13g2_dfrbpq_1
X$10919 VSS \$3266 \$3996 \$4401 \$4175 VDD sg13g2_mux2_1
X$10920 VDD VSS sg13g2_decap_8
X$10922 VDD VSS sg13g2_decap_8
X$10923 VDD VSS sg13g2_decap_8
X$10925 VSS \$4456 \$4333 \$4332 \$3450 VDD sg13g2_dfrbpq_1
X$10938 VDD VSS sg13g2_decap_8
X$10940 VDD VSS sg13g2_decap_8
X$10942 VDD VSS sg13g2_decap_8
X$10947 \$4179 VDD VSS sg13g2_tiehi
X$10949 VDD VSS sg13g2_decap_8
X$10951 VDD VSS sg13g2_decap_8
X$10952 VDD VSS sg13g2_decap_8
X$10954 VDD VSS sg13g2_decap_8
X$10955 VDD VSS sg13g2_decap_4
X$10958 VDD VSS \$4181 \$3317 \$4335 sg13g2_nor2_1
X$10963 VDD VSS sg13g2_decap_8
X$10967 VDD VSS sg13g2_decap_8
X$10968 VDD VSS sg13g2_decap_8
X$10971 VDD VSS sg13g2_decap_8
X$10977 VDD VSS sg13g2_decap_8
X$10986 VDD VSS sg13g2_decap_8
X$10992 VDD VSS sg13g2_decap_8
X$10994 VDD VSS sg13g2_decap_8
X$10996 VDD VSS sg13g2_decap_8
X$10999 VDD VSS sg13g2_decap_8
X$11001 VDD VSS sg13g2_decap_8
X$11002 VDD VSS sg13g2_decap_8
X$11003 VDD VSS sg13g2_decap_8
X$11004 VDD VSS sg13g2_decap_4
X$11006 VSS \$4537 \$4041 \$3053 \$4361 VDD sg13g2_mux2_1
X$11009 VSS VDD \$4361 \$2936 \$4307 sg13g2_nor2b_1
X$11013 VSS \$4308 VDD \$2936 sg13g2_buf_1
X$11018 VDD VSS sg13g2_decap_8
X$11028 VSS \$4429 \$4371 \$3053 \$4255 VDD sg13g2_mux2_1
X$11032 VSS VDD \$4255 \$4308 \$4254 sg13g2_nor2b_1
X$11036 VDD VSS sg13g2_decap_8
X$11042 VDD VSS sg13g2_decap_8
X$11043 VDD VSS sg13g2_decap_4
X$11045 VSS \$4367 \$3981 \$2944 \$4366 VDD sg13g2_mux2_1
X$11046 \$4368 VDD VSS sg13g2_tiehi
X$11051 VDD VSS sg13g2_decap_8
X$11052 VDD VSS sg13g2_decap_8
X$11054 VDD VSS sg13g2_decap_8
X$11055 VDD VSS sg13g2_decap_8
X$11056 VDD VSS sg13g2_decap_8
X$11064 VDD VSS sg13g2_decap_8
X$11068 VDD VSS sg13g2_decap_4
X$11069 VSS \$4372 \$4371 \$2840 \$4374 VDD sg13g2_mux2_1
X$11071 VDD VSS sg13g2_decap_8
X$11076 VSS VDD \$4374 \$4034 \$4262 sg13g2_nor2b_1
X$11081 VDD VSS sg13g2_decap_8
X$11086 VDD VSS sg13g2_decap_8
X$11092 VDD VSS sg13g2_decap_8
X$11093 VDD VSS sg13g2_decap_8
X$11099 VDD VSS sg13g2_decap_4
X$11103 \$4377 VDD VSS sg13g2_tiehi
X$11104 VDD VSS sg13g2_decap_8
X$11105 VDD VSS sg13g2_decap_8
X$11106 VDD VSS sg13g2_decap_4
X$11107 VSS \$4514 \$3981 \$2992 \$4462 VDD sg13g2_mux2_1
X$11108 \$4378 VDD VSS sg13g2_tiehi
X$11110 VDD VSS sg13g2_decap_8
X$11112 VSS VDD \$4462 \$4312 \$4380 sg13g2_nor2b_1
X$11113 VDD VSS sg13g2_decap_8
X$11114 VDD VSS sg13g2_decap_8
X$11119 VDD VSS sg13g2_decap_8
X$11121 VSS \$4385 \$3525 \$4317 \$2992 VDD sg13g2_mux2_1
X$11124 \$4473 VDD VSS sg13g2_tiehi
X$11125 VDD VSS sg13g2_decap_8
X$11127 VSS \$3676 VDD \$4386 sg13g2_buf_1
X$11128 VDD VSS sg13g2_decap_8
X$11129 VDD VSS sg13g2_decap_8
X$11130 VDD VSS sg13g2_decap_8
X$11132 \$4319 VDD VSS sg13g2_tiehi
X$11134 VSS \$4319 \$4259 \$3989 \$4170 VDD sg13g2_dfrbpq_1
X$11137 VDD VSS sg13g2_decap_8
X$11138 VDD VSS sg13g2_decap_8
X$11139 VDD VSS sg13g2_decap_8
X$11140 VDD VSS sg13g2_decap_8
X$11143 VDD VSS sg13g2_decap_8
X$11146 VSS \$4170 \$3556 VDD sg13g2_buf_16
X$11150 VDD VSS sg13g2_decap_4
X$11156 \$4391 VDD VSS sg13g2_tiehi
X$11158 VSS \$4391 \$4324 \$4393 \$4170 VDD sg13g2_dfrbpq_1
X$11159 VDD VSS sg13g2_decap_8
X$11161 VSS VDD \$3899 \$4324 \$4392 sg13g2_nor2b_1
X$11163 \$2993 VSS \$4326 VDD \$4288 \$2990 sg13g2_a21oi_1
X$11167 VSS VDD \$3776 \$4392 \$4324 sg13g2_nor2b_1
X$11169 VDD VSS \$4392 \$4324 \$3750 sg13g2_nand2b_1
X$11171 VDD VSS \$4324 \$4392 \$3894 sg13g2_nand2b_1
X$11172 VDD VSS sg13g2_decap_8
X$11177 \$4341 VSS \$4469 VDD \$4270 \$4327 sg13g2_a21oi_1
X$11178 VDD VSS sg13g2_decap_4
X$11182 VDD VSS \$4175 \$4330 \$4469 sg13g2_nand2b_1
X$11191 VDD VSS \$4270 \$4401 \$4330 sg13g2_nand2_1
X$11193 VDD VSS sg13g2_decap_8
X$11195 VDD VSS \$4288 \$4403 \$3996 sg13g2_nand2_1
X$11197 VDD VSS sg13g2_decap_4
X$11200 VDD VSS \$4326 \$4333 \$4404 sg13g2_nand2_1
X$11202 \$4332 VSS \$4444 VDD \$4438 \$4327 sg13g2_a21oi_1
X$11204 VDD VSS \$4333 \$4330 \$4444 sg13g2_nand2b_1
X$11206 VDD VSS \$4438 \$4403 \$4330 sg13g2_nand2_1
X$11207 VDD VSS sg13g2_decap_4
X$11210 VSS \$4330 VDD \$3754 sg13g2_buf_1
X$11211 VSS \$3996 VDD \$3644 sg13g2_buf_1
X$11213 VDD VSS sg13g2_decap_8
X$11214 VDD VSS sg13g2_decap_8
X$11219 VDD VSS sg13g2_decap_8
X$11221 VDD VSS sg13g2_decap_8
X$11223 VDD VSS sg13g2_decap_8
X$11224 VDD VSS sg13g2_decap_8
X$11225 VDD VSS sg13g2_decap_8
X$11226 VDD VSS sg13g2_decap_8
X$11227 VDD VSS sg13g2_decap_4
X$11228 VSS \$4405 \$3906 \$4335 \$4577 VDD sg13g2_dfrbpq_1
X$11235 VDD VSS sg13g2_decap_8
X$11236 VDD VSS sg13g2_decap_8
X$11238 \$4416 VDD VSS sg13g2_tiehi
X$11239 VSS \$4416 \$4412 \$3225 \$4577 VDD sg13g2_dfrbpq_1
X$11471 VDD VSS sg13g2_decap_8
X$11472 \$4360 VDD VSS sg13g2_tiehi
X$11473 VSS \$4360 \$4307 \$4537 \$3297 VDD sg13g2_dfrbpq_1
X$11474 VDD VSS sg13g2_decap_8
X$11475 VDD VSS sg13g2_decap_4
X$11477 \$4363 VDD VSS sg13g2_tiehi
X$11478 VSS \$4363 \$4254 \$4429 \$3297 VDD sg13g2_dfrbpq_1
X$11479 VDD VSS sg13g2_decap_8
X$11480 VDD VSS sg13g2_decap_4
X$11482 VSS VDD \$4366 \$4034 \$4505 sg13g2_nor2b_1
X$11483 VSS \$4368 \$4505 \$4367 \$4502 VDD sg13g2_dfrbpq_1
X$11489 VDD VSS sg13g2_decap_8
X$11491 VSS \$4598 VDD \$4097 \$4506 \$2990 sg13g2_o21ai_1
X$11494 VSS \$5031 VDD \$2939 \$4507 \$2990 sg13g2_o21ai_1
X$11495 VDD VSS sg13g2_decap_8
X$11497 VDD VSS sg13g2_decap_4
X$11499 \$4373 VDD VSS sg13g2_tiehi
X$11500 VSS \$4373 \$4262 \$4372 \$3439 VDD sg13g2_dfrbpq_1
X$11503 VSS VDD \$4376 \$4034 \$4512 sg13g2_nor2b_1
X$11504 VSS \$4510 \$4371 \$2992 \$4376 VDD sg13g2_mux2_1
X$11505 VSS \$4377 \$4512 \$4510 \$4379 VDD sg13g2_dfrbpq_1
X$11507 VSS \$4378 \$4380 \$4514 \$4379 VDD sg13g2_dfrbpq_1
X$11509 VDD VSS sg13g2_decap_8
X$11514 VDD VSS sg13g2_decap_8
X$11515 VDD VSS sg13g2_decap_4
X$11516 VSS VDD \$4317 \$4312 \$4516 sg13g2_nor2b_1
X$11517 VSS \$4473 \$4516 \$4385 \$4379 VDD sg13g2_dfrbpq_1
X$11518 VDD VSS sg13g2_decap_8
X$11519 VDD VSS sg13g2_decap_8
X$11520 VDD VSS sg13g2_decap_8
X$11521 VDD VSS sg13g2_decap_8
X$11522 VDD VSS sg13g2_decap_8
X$11523 VDD VSS sg13g2_decap_8
X$11524 VDD VSS sg13g2_decap_8
X$11527 VDD VSS \$4561 \$4521 \$4389 \$4394 sg13g2_nor3_1
X$11528 VDD VSS \$4570 \$4323 \$4561 sg13g2_nor2_1
X$11529 VDD VSS \$3883 \$4571 \$4389 sg13g2_nor2_1
X$11530 VDD VSS sg13g2_decap_8
X$11531 VDD VSS sg13g2_decap_8
X$11532 VDD VSS sg13g2_decap_8
X$11534 VSS \$4321 \$4392 \$5171 \$4170 VDD sg13g2_dfrbpq_1
X$11540 VSS VDD \$4393 \$4394 \$4392 sg13g2_nor2b_1
X$11541 VDD VSS sg13g2_decap_8
X$11543 VSS \$4327 VDD \$4394 sg13g2_buf_1
X$11544 VDD VSS sg13g2_decap_8
X$11545 VDD VSS sg13g2_decap_8
X$11546 VDD VSS sg13g2_decap_8
X$11547 VDD VSS sg13g2_decap_8
X$11548 VDD VSS sg13g2_decap_8
X$11549 VDD VSS sg13g2_decap_8
X$11550 VDD VSS sg13g2_decap_8
X$11551 VDD VSS sg13g2_decap_8
X$11552 VDD VSS sg13g2_decap_8
X$11554 VDD VSS sg13g2_decap_8
X$11556 VSS \$4527 VDD \$3899 sg13g2_buf_1
X$11557 VDD VSS sg13g2_decap_8
X$11558 VDD VSS sg13g2_decap_8
X$11559 VDD VSS sg13g2_decap_8
X$11561 VDD VSS \$3996 \$4404 sg13g2_inv_1
X$11563 \$4456 VDD VSS sg13g2_tiehi
X$11564 VDD VSS sg13g2_decap_8
X$11565 VDD VSS sg13g2_decap_8
X$11566 VDD VSS sg13g2_decap_8
X$11567 VDD VSS sg13g2_decap_8
X$11568 VDD VSS sg13g2_decap_8
X$11574 VDD VSS sg13g2_decap_8
X$11575 VDD VSS sg13g2_decap_8
X$11576 VDD VSS sg13g2_decap_8
X$11577 VDD VSS sg13g2_decap_4
X$11579 VSS \$3740 \$3644 \$4532 \$4578 VDD sg13g2_mux2_1
X$11580 VDD VSS sg13g2_decap_8
X$11581 VDD VSS sg13g2_decap_4
X$11583 \$4405 VDD VSS sg13g2_tiehi
X$11584 VSS \$3175 \$3644 \$4533 \$4408 VDD sg13g2_mux2_1
X$11585 VDD VSS \$4542 \$4533 \$4406 sg13g2_nand2_1
X$11586 \$4535 VSS \$4407 VDD \$4542 \$4534 sg13g2_a21oi_1
X$11587 VDD VSS \$4408 \$4406 \$4407 sg13g2_nand2b_1
X$11588 VDD VSS sg13g2_decap_4
X$11589 \$4673 VDD VSS sg13g2_tiehi
X$11590 VDD VSS sg13g2_decap_8
X$11591 VDD VSS sg13g2_decap_8
X$11592 VDD VSS sg13g2_decap_8
X$11593 VDD VSS sg13g2_decap_8
X$11594 VDD VSS sg13g2_decap_4
X$11596 VSS SCAN_OUT VDD \$4412 sg13g2_buf_1
X$11597 VDD VSS sg13g2_decap_8
X$11598 VDD VSS sg13g2_decap_8
X$11602 VDD VSS sg13g2_decap_8
X$11604 VDD VSS sg13g2_decap_8
X$11608 VDD VSS sg13g2_decap_8
X$11609 VDD VSS sg13g2_decap_8
X$11612 VDD VSS sg13g2_decap_8
X$11615 \$4620 VDD VSS sg13g2_tiehi
X$11619 VDD VSS sg13g2_decap_8
X$11621 VDD VSS sg13g2_decap_8
X$11624 VDD VSS sg13g2_decap_8
X$11625 VDD VSS sg13g2_decap_8
X$11628 VDD VSS sg13g2_decap_8
X$11630 \$4622 VDD VSS sg13g2_tiehi
X$11639 VSS \$4624 \$4041 \$2944 \$4685 VDD sg13g2_mux2_1
X$11645 VSS VDD \$4685 \$4503 \$4564 sg13g2_nor2b_1
X$11648 VSS \$3870 \$4565 \$3676 \$4621 \$4505 \$4564 \$4627 VDD sg13g2_mux4_1
X$11658 VSS \$4698 \$4259 \$3769 \$4565 VDD sg13g2_mux2_1
X$11665 VSS VDD \$4628 \$4503 \$4627 sg13g2_nor2b_1
X$11667 VDD VSS sg13g2_decap_8
X$11671 VDD VSS sg13g2_decap_8
X$11674 \$4631 VDD VSS sg13g2_tiehi
X$11675 VDD VSS sg13g2_decap_8
X$11678 VDD VSS sg13g2_decap_8
X$11683 VDD VSS sg13g2_decap_8
X$11686 VDD VSS sg13g2_decap_8
X$11695 VDD VSS sg13g2_decap_8
X$11698 VDD VSS sg13g2_decap_8
X$11700 VDD VSS sg13g2_decap_8
X$11704 VDD VSS sg13g2_decap_8
X$11705 VDD VSS sg13g2_decap_8
X$11711 VSS \$I34317 \$4566 VDD sg13g2_buf_16
X$11722 VSS \$3774 \$4613 \$3676 \$4161 \$4380 \$4808 \$4512 VDD sg13g2_mux4_1
X$11730 VDD VSS sg13g2_decap_8
X$11737 VSS VDD \$4720 \$4312 \$4643 sg13g2_nor2b_1
X$11738 VDD VSS sg13g2_decap_4
X$11741 VSS \$3774 \$4569 \$3676 \$4516 \$3683 \$4643 \$4646 VDD sg13g2_mux4_1
X$11745 VDD VSS sg13g2_decap_4
X$11746 VSS \$4570 \$4259 \$4569 \$4613 VDD sg13g2_mux2_1
X$11747 VDD VSS sg13g2_decap_8
X$11750 VDD VSS sg13g2_decap_8
X$11751 VDD VSS sg13g2_decap_8
X$11753 \$4735 VDD VSS sg13g2_tiehi
X$11755 VSS \$4735 \$4571 \$4521 \$4170 VDD sg13g2_dfrbpq_1
X$11770 VDD VSS sg13g2_decap_8
X$11771 VDD VSS sg13g2_decap_8
X$11773 VDD VSS sg13g2_decap_8
X$11775 VDD VSS sg13g2_decap_8
X$11779 VDD VSS sg13g2_decap_8
X$11781 VDD VSS sg13g2_decap_8
X$11789 \$4750 VDD VSS sg13g2_tiehi
X$11791 VSS \$4750 \$2206 \$4654 \$4800 VDD sg13g2_dfrbpq_1
X$11796 VDD VSS sg13g2_decap_8
X$11797 VDD VSS sg13g2_decap_8
X$11799 \$4659 VDD VSS sg13g2_tiehi
X$11801 VSS \$4659 \$4574 \$4660 \$4800 VDD sg13g2_dfrbpq_1
X$11806 \$4660 VSS \$4573 VDD \$4748 \$4327 sg13g2_a21oi_1
X$11810 VDD VSS \$4574 \$4330 \$4573 sg13g2_nand2b_1
X$11812 VDD VSS \$4748 \$4661 \$4330 sg13g2_nand2_1
X$11813 VDD VSS sg13g2_decap_4
X$11815 \$4506 VSS \$4404 VDD \$4574 \$4575 sg13g2_a21oi_1
X$11816 VDD VSS sg13g2_decap_8
X$11819 VDD VSS sg13g2_decap_8
X$11822 VDD VSS sg13g2_decap_8
X$11824 VDD VSS sg13g2_decap_8
X$11825 VDD VSS sg13g2_decap_8
X$11827 VDD VSS sg13g2_decap_8
X$11829 \$4711 VDD VSS sg13g2_tiehi
X$11831 VSS \$4711 \$4578 \$4708 \$4577 VDD sg13g2_dfrbpq_1
X$11832 \$4708 VSS \$4668 VDD \$4580 \$4534 sg13g2_a21oi_1
X$11837 VDD VSS \$4578 \$4406 \$4668 sg13g2_nand2b_1
X$11839 VDD VSS sg13g2_decap_8
X$11841 VDD VSS \$4577 \$I35510 sg13g2_inv_1
X$11843 VSS \$4577 \$4583 VDD sg13g2_buf_16
X$11871 VSS \$4673 \$4408 \$4535 \$4577 VDD sg13g2_dfrbpq_1
X$11874 VDD VSS sg13g2_decap_8
X$11875 VDD VSS sg13g2_decap_8
X$11876 VDD VSS sg13g2_decap_4
X$12092 VDD VSS sg13g2_decap_8
X$12093 VDD VSS sg13g2_decap_8
X$12094 VDD VSS sg13g2_decap_8
X$12095 VDD VSS sg13g2_decap_8
X$12096 VDD VSS sg13g2_decap_8
X$12097 VDD VSS sg13g2_decap_8
X$12098 VDD VSS sg13g2_decap_8
X$12100 VSS \$4620 \$4621 \$4779 \$3297 VDD sg13g2_dfrbpq_1
X$12101 \$4034 \$4779 \$4621 VDD VSS sg13g2_or2_1
X$12102 VDD VSS sg13g2_decap_8
X$12104 VSS \$4622 \$4564 \$4624 \$4502 VDD sg13g2_dfrbpq_1
X$12109 VDD VSS sg13g2_decap_8
X$12110 VDD VSS sg13g2_decap_8
X$12112 VSS \$3979 \$1620 VDD sg13g2_buf_16
X$12116 VSS \$4629 \$4371 \$2944 \$4628 VDD sg13g2_mux2_1
X$12118 VSS \$4631 \$4627 \$4629 \$4502 VDD sg13g2_dfrbpq_1
X$12119 VDD VSS sg13g2_decap_8
X$12120 VDD VSS sg13g2_decap_8
X$12121 VDD VSS sg13g2_decap_8
X$12122 VDD VSS sg13g2_decap_8
X$12123 VDD VSS sg13g2_decap_8
X$12124 VDD VSS sg13g2_decap_8
X$12126 VSS \$4566 \$1620 VDD sg13g2_buf_16
X$12133 VSS \$4841 \$2984 \$4720 \$2992 VDD sg13g2_mux2_1
X$12134 VSS \$4379 \$4566 VDD sg13g2_buf_16
X$12136 VSS \$4726 \$3795 \$4728 \$2992 VDD sg13g2_mux2_1
X$12141 VSS VDD \$4728 \$4312 \$4646 sg13g2_nor2b_1
X$12144 \$4727 VDD VSS sg13g2_tiehi
X$12145 VSS \$4727 \$4646 \$4726 \$4379 VDD sg13g2_dfrbpq_1
X$12147 VDD VSS sg13g2_decap_8
X$12148 VDD VSS sg13g2_decap_8
X$12149 VDD VSS sg13g2_decap_8
X$12150 VDD VSS sg13g2_decap_8
X$12151 VDD VSS sg13g2_decap_4
X$12152 VSS VDD \$4650 \$4651 \$4571 sg13g2_nor2b_1
X$12153 \$4746 VSS \$4570 VDD \$4651 \$4650 sg13g2_a21oi_1
X$12154 VDD VSS sg13g2_decap_8
X$12155 VDD VSS sg13g2_decap_8
X$12156 VDD VSS sg13g2_decap_4
X$12158 VDD VSS \$4773 \$4839 \$4653 \$4394 sg13g2_nor3_1
X$12160 VDD VSS \$3883 \$4812 \$4653 sg13g2_nor2_1
X$12165 VDD VSS sg13g2_decap_8
X$12166 VDD VSS sg13g2_decap_8
X$12167 VDD VSS sg13g2_decap_8
X$12168 VDD VSS sg13g2_decap_8
X$12169 VDD VSS sg13g2_decap_4
X$12170 \$4657 VDD VSS sg13g2_tiehi
X$12171 VSS \$3556 \$1620 VDD sg13g2_buf_16
X$12172 VDD VSS sg13g2_decap_4
X$12174 VSS \$4942 VDD \$3776 sg13g2_buf_1
X$12175 VDD VSS sg13g2_decap_8
X$12176 VDD VSS sg13g2_decap_8
X$12177 VDD VSS sg13g2_decap_8
X$12178 VDD VSS sg13g2_decap_8
X$12179 VDD VSS sg13g2_decap_8
X$12180 VDD VSS sg13g2_decap_4
X$12181 VDD VSS \$4575 \$4661 \$3996 sg13g2_and2_1
X$12182 VDD VSS sg13g2_decap_8
X$12185 \$4507 VSS \$4404 VDD \$4787 \$4723 sg13g2_a21oi_1
X$12186 VDD VSS sg13g2_decap_4
X$12188 VDD VSS \$4723 \$4816 \$3996 sg13g2_and2_1
X$12189 VDD VSS sg13g2_decap_8
X$12191 VSS \$2960 \$3996 \$4987 \$4670 VDD sg13g2_mux2_1
X$12196 VDD VSS sg13g2_decap_4
X$12198 VSS \$I34346 \$4583 VDD sg13g2_buf_16
X$12200 VDD VSS \$4580 \$4532 \$4406 sg13g2_nand2_1
X$12201 VSS \$4406 VDD \$3754 sg13g2_buf_1
X$12202 VDD VSS sg13g2_decap_8
X$12203 VDD VSS sg13g2_decap_4
X$12204 VSS \$3358 \$3644 \$4819 \$4672 VDD sg13g2_mux2_1
X$12205 VDD VSS sg13g2_decap_8
X$12207 VDD VSS sg13g2_decap_8
X$12208 VDD VSS sg13g2_decap_8
X$12209 VDD VSS sg13g2_decap_8
X$12210 VDD VSS sg13g2_decap_8
X$12211 VDD VSS sg13g2_decap_8
X$12212 VDD VSS sg13g2_decap_8
X$12213 VDD VSS sg13g2_decap_8
X$12214 VDD VSS sg13g2_decap_8
X$12217 VDD VSS sg13g2_decap_4
X$12219 \$4877 VDD VSS sg13g2_tiehi
X$12220 VSS \$4877 \$4849 \$4830 \$4502 VDD sg13g2_dfrbpq_1
X$12223 VSS VDD \$4885 \$4308 \$4849 sg13g2_nor2b_1
X$12224 VSS \$4830 \$3525 \$4885 \$4598 VDD sg13g2_mux2_1
X$12229 \$4850 VDD VSS sg13g2_tiehi
X$12231 VDD VSS sg13g2_decap_8
X$12233 VDD VSS sg13g2_decap_8
X$12234 VDD VSS sg13g2_decap_8
X$12236 VDD VSS sg13g2_decap_8
X$12241 VDD VSS sg13g2_decap_8
X$12247 \$4502 \$I36906 VSS VDD sg13g2_inv_2
X$12248 VSS \$4502 \$3979 VDD sg13g2_buf_16
X$12254 VDD VSS sg13g2_decap_8
X$12255 VDD VSS sg13g2_decap_8
X$12257 VDD VSS sg13g2_decap_8
X$12259 VDD VSS sg13g2_decap_8
X$12260 VDD VSS sg13g2_decap_8
X$12264 VDD VSS sg13g2_decap_8
X$12268 VDD VSS sg13g2_decap_8
X$12271 VDD VSS sg13g2_decap_8
X$12272 VDD VSS sg13g2_decap_8
X$12277 VDD VSS sg13g2_decap_8
X$12278 VDD VSS sg13g2_decap_8
X$12280 VDD VSS sg13g2_decap_8
X$12281 VDD VSS sg13g2_decap_8
X$12282 VDD VSS sg13g2_decap_8
X$12283 VDD VSS sg13g2_decap_8
X$12286 \$4899 VDD VSS sg13g2_tiehi
X$12287 VSS \$4899 \$4808 \$4854 \$4379 VDD sg13g2_dfrbpq_1
X$12297 VSS VDD \$5008 \$4312 \$4808 sg13g2_nor2b_1
X$12299 VDD VSS sg13g2_decap_8
X$12310 VSS \$4972 \$4643 \$4841 \$4379 VDD sg13g2_dfrbpq_1
X$12322 VDD VSS sg13g2_decap_8
X$12328 VDD VSS sg13g2_decap_8
X$12334 VDD VSS sg13g2_decap_8
X$12340 VDD VSS sg13g2_decap_8
X$12343 VDD VSS sg13g2_decap_8
X$12347 VDD VSS sg13g2_decap_8
X$12350 VDD VSS sg13g2_decap_4
X$12352 \$5015 VDD VSS sg13g2_tiehi
X$12353 VDD VSS sg13g2_decap_8
X$12354 VDD VSS sg13g2_decap_8
X$12355 VDD VSS sg13g2_decap_4
X$12358 VDD VSS \$4908 \$4845 \$4857 \$4394 sg13g2_nor3_1
X$12359 VDD VSS \$4698 \$4323 \$4908 sg13g2_nor2_1
X$12361 VDD VSS sg13g2_decap_4
X$12368 VSS \$4651 VDD \$3745 sg13g2_buf_1
X$12374 VDD VSS sg13g2_decap_8
X$12375 \$4861 VDD VSS sg13g2_tiehi
X$12376 VSS \$4861 \$4812 \$4839 \$4800 VDD sg13g2_dfrbpq_1
X$12391 VDD VSS sg13g2_decap_8
X$12392 VDD VSS \$4746 \$4862 \$4918 sg13g2_nor2_1
X$12394 VDD VSS \$4813 \$4327 \$4916 sg13g2_nor2_1
X$12395 \$4813 VSS \$3691 VDD \$4863 \$4918 sg13g2_a21oi_1
X$12396 VDD VSS \$3556 \$I36197 sg13g2_inv_4
X$12398 VSS \$4657 \$4863 \$4916 \$4800 VDD sg13g2_dfrbpq_1
X$12408 VDD VSS sg13g2_decap_8
X$12414 \$4944 VDD VSS sg13g2_tiehi
X$12415 VDD VSS sg13g2_decap_8
X$12419 VDD VSS sg13g2_decap_8
X$12420 VDD VSS sg13g2_decap_8
X$12421 VDD VSS sg13g2_decap_8
X$12422 VDD VSS sg13g2_decap_8
X$12423 VDD VSS sg13g2_decap_8
X$12428 VDD VSS sg13g2_decap_8
X$12430 VDD VSS sg13g2_decap_8
X$12439 VDD VSS sg13g2_decap_8
X$12443 VDD VSS sg13g2_decap_8
X$12447 VDD VSS sg13g2_decap_8
X$12454 VDD VSS \$4867 \$4816 \$3754 sg13g2_nand2_1
X$12457 VDD VSS \$4787 \$3754 \$5009 sg13g2_nand2b_1
X$12460 VSS \$4583 \$1620 VDD sg13g2_buf_16
X$12463 \$4996 VDD VSS sg13g2_tiehi
X$12466 VDD VSS sg13g2_decap_8
X$12473 VDD VSS sg13g2_decap_8
X$12474 VDD VSS sg13g2_decap_8
X$12477 VDD VSS sg13g2_decap_4
X$12483 VDD VSS \$4821 \$4819 \$4406 sg13g2_nand2_1
X$12485 \$4884 VSS \$4827 VDD \$4821 \$4534 sg13g2_a21oi_1
X$12487 VDD VSS \$4672 \$4406 \$4827 sg13g2_nand2b_1
X$12488 VSS \$4881 \$4672 \$4884 \$5047 VDD sg13g2_dfrbpq_1
X$12491 \$4881 VDD VSS sg13g2_tiehi
X$12492 VDD VSS sg13g2_decap_8
X$12493 VDD VSS sg13g2_decap_8
X$12494 VDD VSS sg13g2_decap_4
X$12497 VDD VSS sg13g2_decap_8
X$12498 VDD VSS sg13g2_decap_8
X$12505 VDD VSS sg13g2_decap_8
X$12506 VDD VSS sg13g2_decap_8
X$12511 VDD VSS sg13g2_decap_8
X$12512 VDD VSS sg13g2_decap_4
X$12521 VSS \$4925 \$3795 \$5115 \$4598 VDD sg13g2_mux2_1
X$12529 VSS \$4850 \$5030 \$4925 \$4502 VDD sg13g2_dfrbpq_1
X$12532 VDD VSS sg13g2_decap_8
X$12533 VDD VSS sg13g2_decap_8
X$12534 VDD VSS sg13g2_decap_8
X$12537 VSS \$5121 \$3525 \$4928 \$5031 VDD sg13g2_mux2_1
X$12541 VDD VSS sg13g2_decap_8
X$12544 VSS VDD \$4928 \$4503 \$5032 sg13g2_nor2b_1
X$12546 VDD VSS sg13g2_decap_8
X$12549 VDD VSS sg13g2_decap_8
X$12552 VDD VSS sg13g2_decap_8
X$12553 VDD VSS sg13g2_decap_8
X$12554 VDD VSS sg13g2_decap_8
X$12555 VDD VSS sg13g2_decap_8
X$12556 VDD VSS sg13g2_decap_8
X$12557 VDD VSS sg13g2_decap_8
X$12558 VDD VSS sg13g2_decap_8
X$12562 VDD VSS sg13g2_decap_8
X$12564 VSS \$5038 VDD \$4034 sg13g2_buf_1
X$12565 VSS \$4968 \$3525 \$5005 \$3198 VDD sg13g2_mux2_1
X$12566 VDD VSS sg13g2_decap_8
X$12567 VDD VSS sg13g2_decap_8
X$12568 VDD VSS sg13g2_decap_8
X$12569 VDD VSS sg13g2_decap_8
X$12575 \$5149 VDD VSS sg13g2_tiehi
X$12580 VSS \$4854 \$4041 \$2992 \$5008 VDD sg13g2_mux2_1
X$12583 VDD VSS sg13g2_decap_8
X$12585 VDD VSS sg13g2_decap_8
X$12592 VDD VSS sg13g2_decap_8
X$12594 VDD VSS sg13g2_decap_4
X$12596 \$4972 VDD VSS sg13g2_tiehi
X$12598 VDD VSS sg13g2_decap_8
X$12599 VDD VSS sg13g2_decap_8
X$12601 VDD VSS sg13g2_decap_8
X$12603 VDD VSS sg13g2_decap_8
X$12604 VDD VSS sg13g2_decap_8
X$12606 VSS \$5089 VDD \$4312 sg13g2_buf_1
X$12607 VDD VSS sg13g2_decap_8
X$12608 VDD VSS sg13g2_decap_8
X$12609 VDD VSS sg13g2_decap_8
X$12613 VDD VSS sg13g2_decap_4
X$12615 VSS \$5015 \$4975 \$4845 \$4800 VDD sg13g2_dfrbpq_1
X$12617 VDD VSS \$3883 \$4975 \$4857 sg13g2_nor2_1
X$12625 VSS VDD \$4933 \$3745 \$4975 sg13g2_nor2b_1
X$12631 \$4967 VSS \$4698 VDD \$4651 \$4933 sg13g2_a21oi_1
X$12634 VDD VSS sg13g2_decap_8
X$12636 VDD VSS sg13g2_decap_8
X$12638 VDD VSS sg13g2_decap_8
X$12642 VDD VSS \$4323 \$4226 \$4773 sg13g2_nor2_1
X$12644 VDD VSS sg13g2_decap_8
X$12648 VSS VDD \$4936 \$4651 \$4812 sg13g2_nor2b_1
X$12650 \$4937 VSS \$4226 VDD \$4651 \$4936 sg13g2_a21oi_1
X$12651 VSS \$4800 \$3556 VDD sg13g2_buf_16
X$12672 VDD VSS sg13g2_decap_8
X$12674 VDD VSS sg13g2_decap_8
X$12677 VDD VSS sg13g2_decap_8
X$12678 VDD VSS sg13g2_decap_4
X$12683 \$4943 VSS \$4963 VDD \$4941 \$4327 sg13g2_a21oi_1
X$12684 VSS \$4944 \$4401 \$4943 \$4945 VDD sg13g2_dfrbpq_1
X$12689 VDD VSS \$4963 \$4401 \$4946 sg13g2_nand2_1
X$12690 VSS \$4948 VDD \$3894 sg13g2_buf_1
X$12691 VDD VSS sg13g2_decap_8
X$12692 VSS \$4946 VDD \$3750 sg13g2_buf_1
X$12693 VDD VSS sg13g2_decap_4
X$12695 VDD VSS \$4958 \$4403 \$4942 sg13g2_nand2_1
X$12696 \$4961 VSS \$4947 VDD \$4958 \$4984 sg13g2_a21oi_1
X$12698 VDD VSS \$4947 \$5044 \$4948 sg13g2_nand2_1
X$12700 VDD VSS sg13g2_decap_8
X$12702 VDD VSS sg13g2_decap_8
X$12703 VDD VSS sg13g2_decap_8
X$12709 VDD VSS sg13g2_decap_4
X$12714 \$4986 VSS \$5009 VDD \$4867 \$4984 sg13g2_a21oi_1
X$12715 VDD VSS sg13g2_decap_4
X$12716 VSS \$4996 \$4787 \$4986 \$4577 VDD sg13g2_dfrbpq_1
X$12720 VDD VSS sg13g2_decap_8
X$12721 VDD VSS sg13g2_decap_8
X$12724 VDD VSS sg13g2_decap_8
X$12728 VDD VSS \$4670 \$4406 \$4990 sg13g2_nand2b_1
X$12738 \$4988 VSS \$4990 VDD \$4952 \$4534 sg13g2_a21oi_1
X$12744 VDD VSS \$4952 \$4987 \$4406 sg13g2_nand2_1
X$12752 VDD VSS sg13g2_decap_8
X$12755 VDD VSS sg13g2_decap_8
X$12757 VDD VSS sg13g2_decap_8
X$12758 VDD VSS sg13g2_decap_8
X$12763 VDD VSS sg13g2_decap_8
X$12764 VDD VSS sg13g2_decap_8
X$12765 VDD VSS sg13g2_decap_4
X$12767 VDD VSS sg13g2_decap_8
X$12768 VDD VSS sg13g2_decap_8
X$12769 VDD VSS sg13g2_decap_8
X$12770 VDD VSS sg13g2_decap_4
X$12773 \$5065 VDD VSS sg13g2_tiehi
X$12776 VDD VSS sg13g2_decap_8
X$12777 VDD VSS sg13g2_decap_8
X$12779 VDD VSS sg13g2_decap_8
X$12783 VDD VSS sg13g2_decap_8
X$12786 VDD VSS sg13g2_decap_8
X$12787 VSS VDD \$5115 \$4308 \$5030 sg13g2_nor2b_1
X$12790 VDD VSS sg13g2_decap_8
X$12791 VDD VSS sg13g2_decap_8
X$12793 VDD VSS sg13g2_decap_8
X$12794 VDD VSS sg13g2_decap_8
X$12797 VSS \$5070 \$5032 \$5121 \$4502 VDD sg13g2_dfrbpq_1
X$12814 VDD VSS sg13g2_decap_4
X$12815 VSS VDD \$5131 \$4503 \$5072 sg13g2_nor2b_1
X$12817 VSS \$5073 \$3795 \$5131 \$5031 VDD sg13g2_mux2_1
X$12818 VSS \$5035 \$5072 \$5073 \$5433 VDD sg13g2_dfrbpq_1
X$12819 VDD VSS sg13g2_decap_8
X$12821 \$5075 VDD VSS sg13g2_tiehi
X$12824 VSS \$5075 \$5076 \$4968 \$5037 VDD sg13g2_dfrbpq_1
X$12837 VSS VDD \$5005 \$5038 \$5076 sg13g2_nor2b_1
X$12841 VSS VDD \$5078 \$5038 \$5080 sg13g2_nor2b_1
X$12842 VSS \$5079 \$3795 \$5078 \$3198 VDD sg13g2_mux2_1
X$12844 VSS \$5149 \$5080 \$5079 \$4379 VDD sg13g2_dfrbpq_1
X$12855 VDD VSS sg13g2_decap_8
X$12857 VDD VSS sg13g2_decap_8
X$12858 \$5157 VDD VSS sg13g2_tiehi
X$12861 VSS \$5157 \$5085 \$5081 \$4379 VDD sg13g2_dfrbpq_1
X$12863 VDD VSS sg13g2_decap_4
X$12865 VSS \$5167 \$3795 \$5164 \$3356 VDD sg13g2_mux2_1
X$12867 VDD VSS sg13g2_decap_8
X$12869 VDD VSS sg13g2_decap_8
X$12870 \$5088 VDD VSS sg13g2_tiehi
X$12873 VDD VSS sg13g2_decap_8
X$12874 VDD VSS sg13g2_decap_8
X$12877 VDD VSS sg13g2_decap_8
X$12878 VSS \$4394 VDD \$5089 sg13g2_buf_1
X$12881 VDD VSS sg13g2_decap_8
X$12882 VDD VSS sg13g2_decap_8
X$12888 VDD VSS sg13g2_decap_8
X$12894 VDD VSS sg13g2_decap_8
X$12902 VDD VSS sg13g2_decap_8
X$12903 VDD VSS sg13g2_decap_8
X$12905 VDD VSS sg13g2_decap_8
X$12908 VDD VSS sg13g2_decap_8
X$12916 VDD VSS sg13g2_decap_8
X$12918 VDD VSS sg13g2_decap_8
X$12928 \$4800 \$I36905 VSS VDD sg13g2_inv_2
X$12931 VDD VSS sg13g2_decap_4
X$12933 VDD VSS \$4967 \$4862 \$5309 sg13g2_nor2_1
X$12935 VDD VSS sg13g2_decap_8
X$12940 \$5204 VDD VSS sg13g2_tiehi
X$12941 VDD VSS sg13g2_decap_8
X$12942 VDD VSS sg13g2_decap_8
X$12943 VDD VSS sg13g2_decap_8
X$12945 VDD VSS \$4941 \$5093 \$4527 sg13g2_nand2_1
X$12949 VDD VSS sg13g2_decap_8
X$12956 VDD VSS sg13g2_decap_8
X$12961 VDD VSS \$5042 \$4401 \$4942 sg13g2_nand2_1
X$12964 VDD VSS sg13g2_decap_8
X$12965 VDD VSS sg13g2_decap_8
X$12976 \$5155 VDD VSS sg13g2_tiehi
X$12977 VSS \$5155 \$5044 \$4961 \$4945 VDD sg13g2_dfrbpq_1
X$12999 VSS \$5128 \$3897 \$5044 \$4863 VDD sg13g2_mux2_1
X$13002 VDD VSS \$5128 \$4946 \$5100 sg13g2_nor2_1
X$13005 VDD VSS sg13g2_decap_8
X$13011 VDD VSS sg13g2_decap_8
X$13019 VDD VSS sg13g2_decap_8
X$13023 VDD VSS sg13g2_decap_8
X$13026 VDD VSS sg13g2_decap_8
X$13028 VDD VSS sg13g2_decap_8
X$13030 VDD VSS sg13g2_decap_8
X$13033 VDD VSS sg13g2_decap_8
X$13034 VDD VSS sg13g2_decap_8
X$13035 VDD VSS sg13g2_decap_8
X$13036 VDD VSS sg13g2_decap_4
X$13042 \$5220 VDD VSS sg13g2_tiehi
X$13048 VDD VSS sg13g2_decap_8
X$13057 VDD VSS sg13g2_decap_8
X$13059 \$5109 VDD VSS sg13g2_tiehi
X$13060 VSS \$5109 \$4670 \$4988 \$5047 VDD sg13g2_dfrbpq_1
X$13062 VDD VSS sg13g2_decap_4
X$13064 VDD VSS sg13g2_decap_8
X$13065 VDD VSS sg13g2_decap_8
X$13066 VDD VSS sg13g2_decap_8
X$13069 VSS \$5275 \$2984 \$5222 \$4598 VDD sg13g2_mux2_1
X$13074 VDD VSS sg13g2_decap_8
X$13076 VSS VDD \$5222 \$4308 \$5276 sg13g2_nor2b_1
X$13078 VDD VSS sg13g2_decap_8
X$13080 VSS \$3870 \$5188 \$5186 \$4849 \$5187 \$5276 \$5030 VDD sg13g2_mux4_1
X$13087 VDD VSS sg13g2_decap_8
X$13089 VDD VSS sg13g2_decap_8
X$13090 VDD VSS sg13g2_decap_8
X$13091 VDD VSS sg13g2_decap_4
X$13095 \$5070 VDD VSS sg13g2_tiehi
X$13099 VDD VSS sg13g2_decap_4
X$13102 VSS \$5228 VDD \$4034 sg13g2_buf_1
X$13103 VDD VSS sg13g2_decap_8
X$13106 VDD VSS sg13g2_decap_8
X$13109 VDD VSS sg13g2_decap_8
X$13115 VDD VSS sg13g2_decap_8
X$13120 VDD VSS sg13g2_decap_8
X$13126 \$5035 VDD VSS sg13g2_tiehi
X$13128 VDD VSS sg13g2_decap_8
X$13130 VDD VSS sg13g2_decap_8
X$13131 VDD VSS sg13g2_decap_8
X$13134 VDD VSS sg13g2_decap_8
X$13135 VDD VSS sg13g2_decap_8
X$13141 VDD VSS sg13g2_decap_8
X$13143 VDD VSS sg13g2_decap_8
X$13146 VDD VSS sg13g2_decap_8
X$13147 VDD VSS sg13g2_decap_8
X$13153 VDD VSS sg13g2_decap_8
X$13159 VDD VSS sg13g2_decap_8
X$13167 VDD VSS sg13g2_decap_8
X$13171 VDD VSS sg13g2_decap_8
X$13176 VDD VSS sg13g2_decap_8
X$13178 VDD VSS sg13g2_decap_8
X$13179 VDD VSS sg13g2_decap_8
X$13183 VDD VSS sg13g2_decap_8
X$13184 VDD VSS sg13g2_decap_4
X$13185 VSS \$5081 \$3437 \$5082 \$3356 VDD sg13g2_mux2_1
X$13189 VDD VSS sg13g2_decap_8
X$13192 VDD VSS sg13g2_decap_4
X$13194 VSS VDD \$5082 \$5083 \$5085 sg13g2_nor2b_1
X$13196 VSS \$5186 VDD \$4386 sg13g2_buf_1
X$13197 VDD VSS sg13g2_decap_8
X$13201 VSS VDD \$5164 \$5083 \$5172 sg13g2_nor2b_1
X$13206 VDD VSS sg13g2_decap_4
X$13209 VSS \$5083 VDD \$5089 sg13g2_buf_1
X$13210 VSS VDD \$5171 \$5089 \$5245 sg13g2_nor2b_1
X$13211 VSS \$5088 \$5172 \$5167 \$5251 VDD sg13g2_dfrbpq_1
X$13216 VDD VSS sg13g2_decap_8
X$13219 VDD VSS sg13g2_decap_4
X$13221 VSS VDD \$5256 \$4394 \$5254 sg13g2_nor2b_1
X$13222 VDD VSS sg13g2_decap_8
X$13223 VDD VSS \$4203 \$4323 \$5177 sg13g2_nor2_1
X$13224 VDD VSS \$5177 \$5199 \$5182 \$4394 sg13g2_nor3_1
X$13225 VDD VSS sg13g2_decap_8
X$13227 VDD VSS \$3883 \$5090 \$5182 sg13g2_nor2_1
X$13228 VDD VSS sg13g2_decap_8
X$13229 VSS \$5201 VDD \$3745 sg13g2_buf_1
X$13231 VSS VDD \$5091 \$5201 \$5090 sg13g2_nor2b_1
X$13233 \$5203 VSS \$4203 VDD \$5201 \$5091 sg13g2_a21oi_1
X$13234 VDD VSS sg13g2_decap_4
X$13236 VSS VDD \$4654 \$4394 \$5633 sg13g2_nor2b_1
X$13239 VDD VSS sg13g2_decap_8
X$13240 VDD VSS sg13g2_decap_8
X$13247 VSS \$5204 \$5093 \$5256 \$4945 VDD sg13g2_dfrbpq_1
X$13249 VDD VSS sg13g2_decap_8
X$13254 VDD VSS sg13g2_decap_8
X$13255 VDD VSS sg13g2_decap_8
X$13260 \$5094 VSS \$5264 VDD \$5042 \$4327 sg13g2_a21oi_1
X$13265 VDD VSS sg13g2_decap_8
X$13267 VDD VSS sg13g2_decap_4
X$13271 VDD VSS \$5264 \$5207 \$4948 sg13g2_nand2_1
X$13272 VSS \$5293 \$3897 \$5207 \$5259 VDD sg13g2_mux2_1
X$13280 \$5096 VSS \$5240 VDD \$5243 \$4327 sg13g2_a21oi_1
X$13281 \$5454 VDD VSS sg13g2_tiehi
X$13283 VDD VSS \$5243 \$4661 \$4942 sg13g2_nand2_1
X$13284 VDD VSS sg13g2_decap_8
X$13287 VDD VSS sg13g2_decap_8
X$13292 VDD VSS \$4527 \$4661 \$5132 sg13g2_nor2_1
X$13295 VDD VSS \$5100 \$5288 \$5132 \$4984 sg13g2_nor3_1
X$13303 VDD VSS sg13g2_decap_8
X$13304 VDD VSS sg13g2_decap_8
X$13305 VDD VSS sg13g2_decap_8
X$13306 VDD VSS \$4527 \$4403 \$5102 sg13g2_nor2_1
X$13307 VDD VSS \$5213 \$5214 \$5102 \$4534 sg13g2_nor3_1
X$13308 VSS \$5215 \$4403 \$5214 \$4577 VDD sg13g2_dfrbpq_1
X$13310 VDD VSS \$4527 \$4532 \$5114 sg13g2_nor2_1
X$13311 VDD VSS \$5217 \$5218 \$5114 \$4534 sg13g2_nor3_1
X$13314 VSS \$5220 \$4532 \$5218 \$5047 VDD sg13g2_dfrbpq_1
X$13322 VDD VSS sg13g2_decap_8
X$13326 VDD VSS sg13g2_decap_8
X$13329 VDD VSS sg13g2_decap_8
X$13330 VDD VSS sg13g2_decap_8
X$13333 VDD VSS sg13g2_decap_4
X$13569 VDD VSS sg13g2_decap_8
X$13570 VDD VSS sg13g2_decap_8
X$13571 VDD VSS sg13g2_decap_8
X$13572 VDD VSS sg13g2_decap_8
X$13579 VSS \$5065 \$5276 \$5275 \$5325 VDD sg13g2_dfrbpq_1
X$13581 VSS \$5450 \$3437 \$5277 \$4598 VDD sg13g2_mux2_1
X$13583 VSS VDD \$5277 \$4308 \$5187 sg13g2_nor2b_1
X$13584 VDD VSS sg13g2_decap_8
X$13585 VDD VSS sg13g2_decap_8
X$13586 VDD VSS sg13g2_decap_8
X$13587 VDD VSS sg13g2_decap_8
X$13588 VDD VSS sg13g2_decap_8
X$13589 VDD VSS sg13g2_decap_4
X$13591 VSS \$5383 \$3437 \$5384 \$5031 VDD sg13g2_mux2_1
X$13592 VSS \$4039 \$5280 \$5186 \$5032 \$5331 \$5333 \$5072 VDD sg13g2_mux4_1
X$13594 VDD VSS sg13g2_decap_4
X$13595 VSS \$4503 VDD \$5228 sg13g2_buf_1
X$13596 \$5338 VDD VSS sg13g2_tiehi
X$13597 VDD VSS sg13g2_decap_8
X$13598 VDD VSS sg13g2_decap_8
X$13599 VDD VSS sg13g2_decap_8
X$13600 VDD VSS sg13g2_decap_8
X$13601 VDD VSS sg13g2_decap_8
X$13607 VDD VSS sg13g2_decap_8
X$13609 VSS \$5401 \$3437 \$5282 \$3198 VDD sg13g2_mux2_1
X$13611 VSS VDD \$5282 \$5038 \$5340 sg13g2_nor2b_1
X$13612 VDD VSS sg13g2_decap_8
X$13613 VDD VSS sg13g2_decap_4
X$13614 \$5343 VDD VSS sg13g2_tiehi
X$13616 VSS \$3774 \$5703 \$5186 \$5076 \$5340 \$5344 \$5080 VDD sg13g2_mux4_1
X$13617 VDD VSS sg13g2_decap_8
X$13618 VDD VSS sg13g2_decap_8
X$13619 VDD VSS sg13g2_decap_8
X$13620 VDD VSS sg13g2_decap_8
X$13622 VSS \$5416 \$3525 \$5350 \$3356 VDD sg13g2_mux2_1
X$13625 VDD VSS sg13g2_decap_4
X$13626 VSS VDD \$5350 \$5083 \$5349 sg13g2_nor2b_1
X$13627 VDD VSS sg13g2_decap_4
X$13628 VSS \$3774 \$5355 \$5186 \$5349 \$5085 \$5353 \$5172 VDD sg13g2_mux4_1
X$13630 \$5356 VDD VSS sg13g2_tiehi
X$13631 VDD VSS sg13g2_decap_8
X$13632 VDD VSS sg13g2_decap_8
X$13638 VDD VSS sg13g2_decap_8
X$13639 VDD VSS sg13g2_decap_8
X$13640 VDD VSS sg13g2_decap_8
X$13641 VSS \$5509 VDD \$5089 sg13g2_buf_1
X$13642 VDD VSS sg13g2_decap_8
X$13643 VDD VSS sg13g2_decap_8
X$13645 VDD VSS sg13g2_decap_8
X$13647 \$5357 VDD VSS sg13g2_tiehi
X$13648 VSS \$5357 \$5090 \$5199 \$4800 VDD sg13g2_dfrbpq_1
X$13652 VDD VSS sg13g2_decap_8
X$13654 VDD VSS sg13g2_decap_8
X$13655 VDD VSS sg13g2_decap_8
X$13656 VDD VSS sg13g2_decap_4
X$13658 VDD VSS \$5203 \$4862 \$5423 sg13g2_nor2_1
X$13661 VDD VSS \$4937 \$4862 \$5470 sg13g2_nor2_1
X$13662 VSS \$4862 VDD \$3691 sg13g2_buf_1
X$13663 \$5285 VSS \$4862 VDD \$5259 \$5309 sg13g2_a21oi_1
X$13665 \$5360 VDD VSS sg13g2_tiehi
X$13666 VDD VSS sg13g2_decap_8
X$13667 VDD VSS sg13g2_decap_8
X$13668 VDD VSS sg13g2_decap_8
X$13669 VDD VSS sg13g2_decap_8
X$13670 \$5361 VDD VSS sg13g2_tiehi
X$13676 VSS \$5361 \$5207 \$5094 \$4945 VDD sg13g2_dfrbpq_1
X$13677 VSS \$4945 \$3556 VDD sg13g2_buf_16
X$13678 VDD VSS \$5240 \$5443 \$4948 sg13g2_nand2_1
X$13679 VDD VSS sg13g2_decap_8
X$13680 VDD VSS sg13g2_decap_4
X$13682 \$5364 VDD VSS sg13g2_tiehi
X$13683 VSS \$5364 \$4661 \$5288 \$4945 VDD sg13g2_dfrbpq_1
X$13684 VDD VSS sg13g2_decap_4
X$13686 \$5215 VDD VSS sg13g2_tiehi
X$13687 VDD VSS sg13g2_decap_4
X$13689 VDD VSS \$5293 \$4946 \$5217 sg13g2_nor2_1
X$13690 VDD VSS sg13g2_decap_8
X$13691 VDD VSS sg13g2_decap_8
X$13692 VDD VSS sg13g2_decap_8
X$13694 \$5369 VDD VSS sg13g2_tiehi
X$13695 VDD VSS sg13g2_decap_8
X$13696 VDD VSS sg13g2_decap_8
X$13702 VDD VSS sg13g2_decap_8
X$13703 VDD VSS sg13g2_decap_8
X$13704 VDD VSS sg13g2_decap_4
X$13706 \$5576 VDD VSS sg13g2_tiehi
X$13707 VDD VSS sg13g2_decap_8
X$13708 VDD VSS sg13g2_decap_8
X$13709 VDD VSS sg13g2_decap_8
X$13711 VDD VSS sg13g2_decap_8
X$13712 VDD VSS sg13g2_decap_8
X$13713 VDD VSS sg13g2_decap_8
X$13714 VDD VSS sg13g2_decap_8
X$13715 VDD VSS sg13g2_decap_4
X$13719 VSS \$5484 \$4041 \$4598 \$5430 VDD sg13g2_mux2_1
X$13724 VDD VSS sg13g2_decap_4
X$13727 \$5327 VDD VSS sg13g2_tiehi
X$13728 VSS \$5327 \$5187 \$5450 \$5325 VDD sg13g2_dfrbpq_1
X$13747 VDD VSS sg13g2_decap_8
X$13748 VDD VSS sg13g2_decap_8
X$13749 \$5379 VDD VSS sg13g2_tiehi
X$13750 VSS \$5379 \$5331 \$5383 \$5433 VDD sg13g2_dfrbpq_1
X$13762 VSS VDD \$5384 \$5228 \$5331 sg13g2_nor2b_1
X$13767 VSS VDD \$5488 \$4503 \$5333 sg13g2_nor2b_1
X$13769 VSS \$5457 \$2984 \$5488 \$5031 VDD sg13g2_mux2_1
X$13773 VSS \$5338 \$5333 \$5457 \$5433 VDD sg13g2_dfrbpq_1
X$13779 VDD VSS sg13g2_decap_8
X$13780 \$5339 VDD VSS sg13g2_tiehi
X$13782 VSS \$5339 \$5340 \$5401 \$5037 VDD sg13g2_dfrbpq_1
X$13798 VSS \$5461 \$2984 \$5437 \$3198 VDD sg13g2_mux2_1
X$13799 VSS \$5343 \$5344 \$5461 \$5037 VDD sg13g2_dfrbpq_1
X$13811 VDD VSS sg13g2_decap_8
X$13813 VDD VSS sg13g2_decap_4
X$13816 \$5346 VDD VSS sg13g2_tiehi
X$13817 VSS \$5346 \$5349 \$5416 \$5251 VDD sg13g2_dfrbpq_1
X$13828 VDD VSS sg13g2_decap_8
X$13834 VDD VSS sg13g2_decap_8
X$13840 VSS VDD \$5354 \$5083 \$5353 sg13g2_nor2b_1
X$13845 VSS \$5468 \$2984 \$5354 \$3356 VDD sg13g2_mux2_1
X$13849 VSS \$5356 \$5353 \$5468 \$5251 VDD sg13g2_dfrbpq_1
X$13852 VDD VSS sg13g2_decap_8
X$13853 VDD VSS sg13g2_decap_8
X$13854 VDD VSS sg13g2_decap_8
X$13857 VDD VSS sg13g2_decap_8
X$13858 VDD VSS sg13g2_decap_8
X$13859 VDD VSS sg13g2_decap_8
X$13860 VDD VSS sg13g2_decap_8
X$13864 VDD VSS sg13g2_decap_8
X$13865 VDD VSS sg13g2_decap_8
X$13867 VDD VSS sg13g2_decap_8
X$13870 VDD VSS sg13g2_decap_8
X$13871 VDD VSS sg13g2_decap_8
X$13873 VDD VSS sg13g2_decap_8
X$13874 VDD VSS sg13g2_decap_8
X$13877 VDD VSS sg13g2_decap_8
X$13884 VDD VSS sg13g2_decap_4
X$13891 VDD VSS \$5285 \$5442 \$5359 sg13g2_nor2_1
X$13895 VSS \$5360 \$5259 \$5359 \$4945 VDD sg13g2_dfrbpq_1
X$13902 VDD VSS sg13g2_decap_8
X$13903 VDD VSS sg13g2_decap_8
X$13906 VDD VSS sg13g2_decap_8
X$13909 VDD VSS sg13g2_decap_8
X$13912 VDD VSS sg13g2_decap_8
X$13913 VDD VSS sg13g2_decap_8
X$13917 VDD VSS sg13g2_decap_8
X$13919 VDD VSS sg13g2_decap_4
X$13922 VSS \$5454 \$5443 \$5096 \$4945 VDD sg13g2_dfrbpq_1
X$13935 VDD VSS sg13g2_decap_8
X$13940 VDD VSS sg13g2_decap_8
X$13943 VDD VSS sg13g2_decap_8
X$13946 VDD VSS sg13g2_decap_8
X$13947 VDD VSS sg13g2_decap_4
X$13952 VDD VSS \$5472 \$4946 \$5213 sg13g2_nor2_1
X$13953 VDD VSS sg13g2_decap_8
X$13956 VDD VSS sg13g2_decap_8
X$13962 VDD VSS sg13g2_decap_8
X$13963 VDD VSS sg13g2_decap_8
X$13965 VDD VSS sg13g2_decap_4
X$13966 VSS \$5369 \$4533 \$5444 \$5047 VDD sg13g2_dfrbpq_1
X$13970 VDD VSS \$5478 \$4532 \$4942 sg13g2_nand2_1
X$13972 VDD VSS \$5047 \$I35529 sg13g2_inv_1
X$13973 VSS \$5047 \$4583 VDD sg13g2_buf_16
X$13975 VDD VSS sg13g2_decap_4
X$13977 VDD VSS sg13g2_decap_8
X$13978 \$5543 VDD VSS sg13g2_tiehi
X$13979 VSS \$5543 \$5544 \$5484 \$5325 VDD sg13g2_dfrbpq_1
X$13984 VSS VDD \$5430 \$4308 \$5544 sg13g2_nor2b_1
X$13987 VDD VSS sg13g2_decap_8
X$13990 VDD VSS sg13g2_decap_8
X$13994 VDD VSS sg13g2_decap_8
X$13997 VSS VDD \$5738 \$4308 \$5545 sg13g2_nor2b_1
X$14000 VDD VSS sg13g2_decap_8
X$14001 VDD VSS sg13g2_decap_8
X$14003 VDD VSS sg13g2_decap_8
X$14004 VDD VSS sg13g2_decap_8
X$14007 VDD VSS sg13g2_decap_8
X$14011 VDD VSS sg13g2_decap_8
X$14018 VDD VSS sg13g2_decap_8
X$14020 VDD VSS sg13g2_decap_8
X$14022 VDD VSS sg13g2_decap_8
X$14028 VDD VSS sg13g2_decap_8
X$14036 VDD VSS sg13g2_decap_8
X$14041 VDD VSS sg13g2_decap_8
X$14044 VDD VSS sg13g2_decap_8
X$14047 VDD VSS sg13g2_decap_8
X$14048 VDD VSS sg13g2_decap_8
X$14051 VDD VSS sg13g2_decap_8
X$14052 VDD VSS sg13g2_decap_8
X$14057 VDD VSS sg13g2_decap_4
X$14060 \$5549 VDD VSS sg13g2_tiehi
X$14061 VDD VSS sg13g2_decap_8
X$14063 VSS \$5600 \$4041 \$3198 \$5496 VDD sg13g2_mux2_1
X$14068 VSS VDD \$5496 \$5038 \$5550 sg13g2_nor2b_1
X$14072 VSS VDD \$5437 \$5038 \$5344 sg13g2_nor2b_1
X$14075 VDD VSS sg13g2_decap_8
X$14077 VDD VSS sg13g2_decap_8
X$14080 VDD VSS sg13g2_decap_8
X$14081 VDD VSS sg13g2_decap_8
X$14084 VDD VSS sg13g2_decap_8
X$14085 VDD VSS sg13g2_decap_8
X$14093 VDD VSS sg13g2_decap_8
X$14095 VDD VSS sg13g2_decap_8
X$14097 VDD VSS sg13g2_decap_8
X$14098 VDD VSS sg13g2_decap_8
X$14100 VDD VSS sg13g2_decap_8
X$14101 VDD VSS sg13g2_decap_8
X$14104 VDD VSS sg13g2_decap_8
X$14114 VSS \$5507 \$4259 \$5355 \$5715 VDD sg13g2_mux2_1
X$14118 VDD VSS sg13g2_decap_8
X$14119 VDD VSS sg13g2_decap_8
X$14123 VDD VSS sg13g2_decap_8
X$14126 VDD VSS sg13g2_decap_8
X$14127 VDD VSS sg13g2_decap_8
X$14128 VDD VSS sg13g2_decap_8
X$14129 VDD VSS \$5507 \$4323 \$5510 sg13g2_nor2_1
X$14130 VDD VSS \$5510 \$5553 \$5469 \$5509 sg13g2_nor3_1
X$14131 \$5555 VDD VSS sg13g2_tiehi
X$14132 VDD VSS \$3883 \$5512 \$5469 sg13g2_nor2_1
X$14133 VDD VSS sg13g2_decap_8
X$14134 VDD VSS sg13g2_decap_4
X$14135 VSS VDD \$5557 \$5201 \$5512 sg13g2_nor2b_1
X$14136 \$5498 VSS \$5507 VDD \$5201 \$5557 sg13g2_a21oi_1
X$14137 VDD VSS sg13g2_decap_8
X$14138 VDD VSS sg13g2_decap_8
X$14143 VDD VSS sg13g2_decap_8
X$14144 VDD VSS sg13g2_decap_8
X$14145 VDD VSS sg13g2_decap_8
X$14146 VDD VSS sg13g2_decap_8
X$14148 VDD VSS \$5516 \$5442 \$5640 sg13g2_nor2_1
X$14149 \$5516 VSS \$5517 VDD \$5562 \$5423 sg13g2_a21oi_1
X$14153 VDD VSS sg13g2_decap_4
X$14155 VDD VSS \$5498 \$5517 \$5535 sg13g2_nor2_1
X$14159 VSS \$5491 VDD \$5509 sg13g2_buf_1
X$14161 VDD VSS sg13g2_decap_8
X$14162 VDD VSS sg13g2_decap_8
X$14164 \$5563 VSS \$5517 VDD \$5518 \$5535 sg13g2_a21oi_1
X$14165 VDD VSS \$5563 \$5442 \$5564 sg13g2_nor2_1
X$14168 VSS \$5565 \$5518 \$5564 \$4945 VDD sg13g2_dfrbpq_1
X$14169 VDD VSS sg13g2_decap_8
X$14170 VDD VSS sg13g2_decap_8
X$14171 VDD VSS sg13g2_decap_8
X$14173 VDD VSS sg13g2_decap_8
X$14175 VDD VSS sg13g2_decap_8
X$14178 VDD VSS sg13g2_decap_8
X$14179 VDD VSS sg13g2_decap_8
X$14182 VDD VSS sg13g2_decap_8
X$14187 VDD VSS sg13g2_decap_4
X$14188 VSS \$5624 \$3897 \$5471 \$5518 VDD sg13g2_mux2_1
X$14189 VDD VSS sg13g2_decap_8
X$14193 VDD VSS \$5624 \$4946 \$5521 sg13g2_nor2_1
X$14195 VDD VSS \$5521 \$5569 \$5613 \$4534 sg13g2_nor3_1
X$14196 VDD VSS \$5674 \$4946 \$5523 sg13g2_nor2_1
X$14197 \$5570 VDD VSS sg13g2_tiehi
X$14198 VDD VSS \$4527 \$4819 \$5613 sg13g2_nor2_1
X$14200 VSS \$4534 VDD \$5491 sg13g2_buf_1
X$14201 VDD VSS \$5523 \$5444 \$5573 \$4534 sg13g2_nor3_1
X$14202 VDD VSS \$4527 \$4533 \$5573 sg13g2_nor2_1
X$14204 VDD VSS sg13g2_decap_8
X$14206 VDD VSS sg13g2_decap_8
X$14211 VDD VSS sg13g2_decap_8
X$14213 VDD VSS \$5580 \$5471 \$4948 sg13g2_nand2_1
X$14216 \$5575 VSS \$5580 VDD \$5478 \$5491 sg13g2_a21oi_1
X$14223 VSS \$5576 \$5471 \$5575 \$5047 VDD sg13g2_dfrbpq_1
X$14230 VDD VSS sg13g2_decap_8
X$14231 VDD VSS sg13g2_decap_8
X$14234 VDD VSS sg13g2_decap_8
X$14236 VDD VSS sg13g2_decap_8
X$14241 VDD VSS sg13g2_decap_8
X$14242 VSS \$5585 \$3981 \$4598 \$5706 VDD sg13g2_mux2_1
X$14247 VDD VSS sg13g2_decap_8
X$14248 VSS \$3870 \$5683 \$5186 \$5656 \$5705 \$5544 \$5545 VDD sg13g2_mux4_1
X$14252 VSS \$5667 \$4259 \$5188 \$5683 VDD sg13g2_mux2_1
X$14253 VDD VSS sg13g2_decap_8
X$14254 VDD VSS sg13g2_decap_8
X$14257 VSS \$5746 \$4041 \$5031 \$5657 VDD sg13g2_mux2_1
X$14259 VDD VSS sg13g2_decap_8
X$14261 VSS VDD \$5657 \$4503 \$5783 sg13g2_nor2b_1
X$14262 VDD VSS sg13g2_decap_8
X$14263 VDD VSS sg13g2_decap_8
X$14266 VSS VDD \$5547 \$4503 \$5752 sg13g2_nor2b_1
X$14267 VSS \$5599 \$4259 \$5280 \$5755 VDD sg13g2_mux2_1
X$14268 \$5895 VDD VSS sg13g2_tiehi
X$14269 VDD VSS sg13g2_decap_8
X$14270 VDD VSS sg13g2_decap_8
X$14271 VDD VSS sg13g2_decap_8
X$14272 VDD VSS sg13g2_decap_8
X$14276 VDD VSS sg13g2_decap_4
X$14277 VSS \$5549 \$5550 \$5600 \$5037 VDD sg13g2_dfrbpq_1
X$14288 VDD VSS sg13g2_decap_4
X$14295 VSS \$3774 \$5608 \$5186 \$5896 \$5659 \$5550 \$5660 VDD sg13g2_mux4_1
X$14299 VSS \$5612 \$4259 \$5703 \$5608 VDD sg13g2_mux2_1
X$14302 VDD VSS sg13g2_decap_8
X$14304 VDD VSS sg13g2_decap_8
X$14305 VSS \$5663 \$4041 \$3356 \$5697 VDD sg13g2_mux2_1
X$14307 VDD VSS sg13g2_decap_8
X$14308 VDD VSS sg13g2_decap_8
X$14309 VDD VSS sg13g2_decap_4
X$14311 VSS VDD \$5697 \$5083 \$5665 sg13g2_nor2b_1
X$14312 VDD VSS sg13g2_decap_8
X$14313 VDD VSS sg13g2_decap_8
X$14316 VSS \$5251 \$4566 VDD sg13g2_buf_16
X$14328 VDD VSS sg13g2_decap_8
X$14329 VDD VSS sg13g2_decap_8
X$14330 VDD VSS sg13g2_decap_8
X$14331 VDD VSS sg13g2_decap_8
X$14333 VDD VSS sg13g2_decap_4
X$14344 VSS \$5555 \$5512 \$5553 \$5668 VDD sg13g2_dfrbpq_1
X$14362 \$5558 VDD VSS sg13g2_tiehi
X$14370 VSS \$5558 \$5633 \$5874 \$5668 VDD sg13g2_dfrbpq_1
X$14372 VDD VSS sg13g2_decap_8
X$14373 VDD VSS sg13g2_decap_4
X$14375 \$5639 VDD VSS sg13g2_tiehi
X$14376 VSS \$5639 \$5562 \$5640 \$5668 VDD sg13g2_dfrbpq_1
X$14402 VDD VSS sg13g2_decap_8
X$14403 VDD VSS sg13g2_decap_8
X$14408 VDD VSS sg13g2_decap_8
X$14421 \$5565 VDD VSS sg13g2_tiehi
X$14422 VDD VSS sg13g2_decap_8
X$14424 VDD VSS sg13g2_decap_8
X$14426 VDD VSS sg13g2_decap_8
X$14427 VDD VSS sg13g2_decap_8
X$14430 VDD VSS sg13g2_decap_8
X$14431 VDD VSS sg13g2_decap_8
X$14432 VSS \$5673 \$3897 \$5443 \$5672 VDD sg13g2_mux2_1
X$14433 VDD VSS sg13g2_decap_4
X$14435 VDD VSS \$5673 \$4946 \$5567 sg13g2_nor2_1
X$14437 VDD VSS sg13g2_decap_8
X$14438 \$5722 VDD VSS sg13g2_tiehi
X$14440 VDD VSS sg13g2_decap_8
X$14442 VDD VSS sg13g2_decap_8
X$14444 VDD VSS sg13g2_decap_8
X$14451 VDD VSS sg13g2_decap_8
X$14453 VSS \$5674 \$3897 \$5676 \$5562 VDD sg13g2_mux2_1
X$14467 VSS \$5570 \$4819 \$5569 \$5753 VDD sg13g2_dfrbpq_1
X$14493 VDD VSS sg13g2_decap_8
X$14495 VDD VSS \$5593 \$4819 \$4942 sg13g2_nand2_1
X$14496 VDD VSS sg13g2_decap_8
X$14500 VDD VSS sg13g2_decap_8
X$14510 VDD VSS sg13g2_decap_8
X$14516 VDD VSS sg13g2_decap_8
X$14520 VDD VSS sg13g2_decap_8
X$14521 VDD VSS sg13g2_decap_8
X$14523 VDD VSS sg13g2_decap_8
X$14527 VDD VSS sg13g2_decap_8
X$14528 VDD VSS sg13g2_decap_4
X$14529 VSS \$5781 \$5705 \$5585 \$5325 VDD sg13g2_dfrbpq_1
X$14537 VSS VDD \$5706 \$4308 \$5705 sg13g2_nor2b_1
X$14541 VDD VSS sg13g2_decap_4
X$14545 VSS \$5892 \$4371 \$4598 \$5738 VDD sg13g2_mux2_1
X$14549 VSS \$5325 \$3979 VDD sg13g2_buf_16
X$14564 VDD VSS sg13g2_decap_8
X$14566 \$5837 VDD VSS sg13g2_tiehi
X$14567 VSS \$5837 \$5783 \$5746 \$5325 VDD sg13g2_dfrbpq_1
X$14583 VSS \$4039 \$5755 \$5186 \$5784 \$5922 \$5783 \$5752 VDD sg13g2_mux4_1
X$14586 VSS \$5433 \$3979 VDD sg13g2_buf_16
X$14598 VDD VSS sg13g2_decap_8
X$14599 VDD VSS sg13g2_decap_8
X$14600 VDD VSS sg13g2_decap_8
X$14604 VDD VSS sg13g2_decap_4
X$14607 VSS \$5851 \$3981 \$3198 \$5759 VDD sg13g2_mux2_1
X$14611 VSS VDD \$5759 \$5038 \$5659 sg13g2_nor2b_1
X$14612 VSS VDD \$5856 \$5038 \$5660 sg13g2_nor2b_1
X$14613 VSS \$5037 \$4566 VDD sg13g2_buf_16
X$14622 VDD VSS sg13g2_decap_8
X$14629 VDD VSS sg13g2_decap_8
X$14635 VDD VSS sg13g2_decap_8
X$14640 VDD VSS sg13g2_decap_8
X$14641 \$5795 VDD VSS sg13g2_tiehi
X$14645 VSS \$5795 \$5665 \$5663 \$5251 VDD sg13g2_dfrbpq_1
X$14652 VSS \$3774 \$5715 \$5186 \$6060 \$5714 \$5665 \$5796 VDD sg13g2_mux4_1
X$14656 VSS \$5716 \$4371 \$3356 \$5797 VDD sg13g2_mux2_1
X$14658 \$5798 VDD VSS sg13g2_tiehi
X$14660 VSS \$5798 \$5796 \$5716 \$5251 VDD sg13g2_dfrbpq_1
X$14665 VDD VSS sg13g2_decap_8
X$14666 VDD VSS sg13g2_decap_4
X$14669 \$5777 VSS \$5667 VDD \$5201 \$5800 sg13g2_a21oi_1
X$14671 VDD VSS sg13g2_decap_8
X$14673 VDD VSS sg13g2_decap_8
X$14676 VDD VSS sg13g2_decap_8
X$14678 VDD VSS sg13g2_decap_8
X$14680 VDD VSS sg13g2_decap_8
X$14684 VDD VSS sg13g2_decap_8
X$14689 VDD VSS sg13g2_decap_8
X$14693 VDD VSS sg13g2_decap_8
X$14695 VDD VSS sg13g2_decap_8
X$14698 VDD VSS sg13g2_decap_8
X$14699 VDD VSS sg13g2_decap_8
X$14710 VSS \$5517 VDD \$3691 sg13g2_buf_1
X$14711 VDD VSS \$5777 \$3691 \$5881 sg13g2_nor2_1
X$14714 VSS \$5442 VDD \$5509 sg13g2_buf_1
X$14716 VDD VSS sg13g2_decap_8
X$14719 VDD VSS sg13g2_decap_8
X$14720 VDD VSS sg13g2_decap_8
X$14722 VDD VSS sg13g2_decap_8
X$14728 \$5771 VSS \$5517 VDD \$5672 \$5881 sg13g2_a21oi_1
X$14731 VDD VSS \$5771 \$5442 \$5770 sg13g2_nor2_1
X$14732 VDD VSS sg13g2_decap_8
X$14734 \$5719 VDD VSS sg13g2_tiehi
X$14735 VSS \$5719 \$5672 \$5770 \$5753 VDD sg13g2_dfrbpq_1
X$14739 VDD VSS sg13g2_decap_8
X$14744 VDD VSS \$4527 \$4816 \$5814 sg13g2_nor2_1
X$14746 VDD VSS \$5567 \$5815 \$5814 \$4984 sg13g2_nor3_1
X$14753 VSS \$5722 \$4816 \$5815 \$5753 VDD sg13g2_dfrbpq_1
X$14761 VDD VSS sg13g2_decap_8
X$14762 VDD VSS sg13g2_decap_8
X$14768 VDD VSS sg13g2_decap_8
X$14773 VDD VSS sg13g2_decap_8
X$14777 VDD VSS \$4527 \$4987 \$6001 sg13g2_nor2_1
X$14779 VDD VSS sg13g2_decap_8
X$14780 VDD VSS sg13g2_decap_8
X$14783 VDD VSS sg13g2_decap_8
X$14795 \$5735 VSS \$5728 VDD \$5593 \$5491 sg13g2_a21oi_1
X$14797 VDD VSS \$5728 \$5676 \$4948 sg13g2_nand2_1
X$14799 VDD VSS \$5826 \$4533 \$4942 sg13g2_nand2_1
X$14802 VDD VSS sg13g2_decap_8
X$14805 VSS \$5827 \$5676 \$5735 \$5047 VDD sg13g2_dfrbpq_1
X$15010 VDD VSS sg13g2_decap_8
X$15011 VDD VSS sg13g2_decap_8
X$15012 \$5781 VDD VSS sg13g2_tiehi
X$15013 VDD VSS sg13g2_decap_8
X$15014 VDD VSS sg13g2_decap_8
X$15015 VDD VSS sg13g2_decap_8
X$15016 VDD VSS sg13g2_decap_8
X$15017 VDD VSS sg13g2_decap_4
X$15018 \$5832 VDD VSS sg13g2_tiehi
X$15019 VSS \$5832 \$5545 \$5892 \$5325 VDD sg13g2_dfrbpq_1
X$15022 VDD VSS sg13g2_decap_8
X$15023 VDD VSS sg13g2_decap_8
X$15024 VDD VSS sg13g2_decap_8
X$15025 VDD VSS sg13g2_decap_8
X$15027 VDD VSS sg13g2_decap_8
X$15028 VDD VSS sg13g2_decap_8
X$15029 VDD VSS sg13g2_decap_8
X$15030 VDD VSS sg13g2_decap_8
X$15032 VSS \$5788 \$4371 \$5031 \$5547 VDD sg13g2_mux2_1
X$15033 \$5433 \$I36907 VSS VDD sg13g2_inv_2
X$15035 VSS \$5895 \$5752 \$5788 \$5433 VDD sg13g2_dfrbpq_1
X$15036 VDD VSS sg13g2_decap_8
X$15037 VDD VSS sg13g2_decap_4
X$15039 VSS \$5923 \$5659 \$5851 \$5037 VDD sg13g2_dfrbpq_1
X$15046 VDD VSS sg13g2_decap_4
X$15048 VSS VDD \$5925 \$5038 \$5896 sg13g2_nor2b_1
X$15050 VSS \$5793 \$4371 \$3198 \$5856 VDD sg13g2_mux2_1
X$15055 VDD VSS sg13g2_decap_8
X$15057 VDD VSS sg13g2_decap_8
X$15058 VDD VSS sg13g2_decap_8
X$15059 VDD VSS sg13g2_decap_8
X$15061 VDD VSS sg13g2_decap_8
X$15062 VDD VSS sg13g2_decap_8
X$15063 VDD VSS sg13g2_decap_8
X$15064 VDD VSS sg13g2_decap_8
X$15065 VDD VSS sg13g2_decap_8
X$15066 VDD VSS sg13g2_decap_8
X$15067 VDD VSS sg13g2_decap_8
X$15070 VDD VSS \$5251 \$I35520 sg13g2_inv_1
X$15072 VSS VDD \$5797 \$5083 \$5796 sg13g2_nor2b_1
X$15074 VDD VSS sg13g2_decap_8
X$15075 VDD VSS sg13g2_decap_8
X$15076 VDD VSS sg13g2_decap_8
X$15077 VDD VSS sg13g2_decap_8
X$15078 VDD VSS sg13g2_decap_8
X$15081 VDD VSS sg13g2_decap_4
X$15083 VDD VSS \$5667 \$4323 \$5932 sg13g2_nor2_1
X$15084 VSS VDD \$5800 \$5201 \$5899 sg13g2_nor2b_1
X$15085 VDD VSS sg13g2_decap_8
X$15087 VSS VDD \$5874 \$5509 \$5993 sg13g2_nor2b_1
X$15088 VDD VSS \$5612 \$4323 \$5804 sg13g2_nor2_1
X$15089 VDD VSS sg13g2_decap_8
X$15091 VSS VDD \$5806 \$5201 \$5934 sg13g2_nor2b_1
X$15092 \$5886 VSS \$5612 VDD \$5201 \$5806 sg13g2_a21oi_1
X$15093 VDD VSS sg13g2_decap_4
X$15096 VDD VSS \$5668 \$I35515 sg13g2_inv_1
X$15097 VDD VSS \$5599 \$4323 \$5807 sg13g2_nor2_1
X$15098 VDD VSS sg13g2_decap_4
X$15099 VSS VDD \$5808 \$4651 \$5940 sg13g2_nor2b_1
X$15100 \$5879 VSS \$5599 VDD \$4651 \$5808 sg13g2_a21oi_1
X$15101 VDD VSS sg13g2_decap_8
X$15102 VDD VSS sg13g2_decap_8
X$15104 \$5809 VSS \$3691 VDD \$5917 \$5470 sg13g2_a21oi_1
X$15109 VDD VSS \$5879 \$3691 \$6022 sg13g2_nor2_1
X$15110 VDD VSS \$5886 \$5517 \$5887 sg13g2_nor2_1
X$15112 VDD VSS sg13g2_decap_8
X$15113 VDD VSS sg13g2_decap_8
X$15114 VDD VSS sg13g2_decap_8
X$15115 VDD VSS sg13g2_decap_4
X$15117 \$5942 VSS \$5517 VDD \$5916 \$6022 sg13g2_a21oi_1
X$15119 \$5944 VSS \$5517 VDD \$5905 \$5887 sg13g2_a21oi_1
X$15121 VDD VSS sg13g2_decap_8
X$15122 VDD VSS sg13g2_decap_8
X$15123 VDD VSS sg13g2_decap_8
X$15124 VDD VSS sg13g2_decap_8
X$15125 VDD VSS sg13g2_decap_8
X$15126 VDD VSS sg13g2_decap_8
X$15127 VDD VSS sg13g2_decap_8
X$15130 VDD VSS sg13g2_decap_8
X$15131 VDD VSS sg13g2_decap_8
X$15132 VDD VSS \$6041 \$4987 \$4942 sg13g2_nand2_1
X$15133 VDD VSS sg13g2_decap_4
X$15135 VSS \$4984 VDD \$5491 sg13g2_buf_1
X$15136 VDD VSS sg13g2_decap_8
X$15138 VDD VSS \$5950 \$4816 \$4942 sg13g2_nand2_1
X$15139 \$6044 VSS \$5907 VDD \$5950 \$4984 sg13g2_a21oi_1
X$15142 VSS \$5472 \$3897 \$5842 \$5905 VDD sg13g2_mux2_1
X$15144 VDD VSS \$6036 \$4946 \$5913 sg13g2_nor2_1
X$15145 VDD VSS sg13g2_decap_8
X$15148 VDD VSS \$5913 \$5989 \$6001 \$5491 sg13g2_nor3_1
X$15150 VSS \$5952 \$4987 \$5989 \$5753 VDD sg13g2_dfrbpq_1
X$15151 \$5822 VSS \$5825 VDD \$5826 \$5491 sg13g2_a21oi_1
X$15152 VDD VSS \$5825 \$5842 \$4948 sg13g2_nand2_1
X$15154 VDD VSS sg13g2_decap_8
X$15155 VDD VSS sg13g2_decap_4
X$15157 \$5827 VDD VSS sg13g2_tiehi
X$15158 VDD VSS sg13g2_decap_8
X$15159 VDD VSS sg13g2_decap_8
X$15160 VDD VSS sg13g2_decap_4
X$15372 VDD VSS sg13g2_decap_8
X$15373 VDD VSS sg13g2_decap_8
X$15374 VDD VSS sg13g2_decap_8
X$15375 VDD VSS sg13g2_decap_8
X$15378 VDD VSS sg13g2_decap_8
X$15379 VDD VSS sg13g2_decap_8
X$15380 VDD VSS sg13g2_decap_8
X$15381 VDD VSS sg13g2_decap_8
X$15382 VDD VSS sg13g2_decap_8
X$15383 VDD VSS sg13g2_decap_8
X$15385 \$6099 VDD VSS sg13g2_tiehi
X$15386 VDD VSS sg13g2_decap_8
X$15387 VDD VSS sg13g2_decap_8
X$15388 VDD VSS sg13g2_decap_8
X$15389 VDD VSS sg13g2_decap_8
X$15390 VSS \$5921 \$3981 \$5031 \$5963 VDD sg13g2_mux2_1
X$15391 VDD VSS sg13g2_decap_8
X$15392 VDD VSS sg13g2_decap_8
X$15393 VSS VDD \$5963 \$5228 \$5922 sg13g2_nor2b_1
X$15394 VDD VSS sg13g2_decap_8
X$15395 VDD VSS sg13g2_decap_4
X$15396 \$6057 VDD VSS sg13g2_tiehi
X$15397 VDD VSS sg13g2_decap_8
X$15398 VDD VSS sg13g2_decap_8
X$15399 VDD VSS sg13g2_decap_8
X$15400 VDD VSS sg13g2_decap_8
X$15401 VDD VSS sg13g2_decap_4
X$15403 \$6150 VDD VSS sg13g2_tiehi
X$15404 VDD VSS sg13g2_decap_8
X$15408 \$5923 VDD VSS sg13g2_tiehi
X$15409 VDD VSS sg13g2_decap_8
X$15410 VDD VSS sg13g2_decap_8
X$15411 VDD VSS sg13g2_decap_8
X$15412 VDD VSS sg13g2_decap_8
X$15414 \$5976 VDD VSS sg13g2_tiehi
X$15416 VSS \$5976 \$5896 \$5925 \$5037 VDD sg13g2_dfrbpq_1
X$15417 VDD VSS sg13g2_decap_8
X$15418 VDD VSS sg13g2_decap_8
X$15419 VDD VSS sg13g2_decap_8
X$15421 VSS \$6102 \$3981 \$3356 \$5988 VDD sg13g2_mux2_1
X$15422 VDD VSS sg13g2_decap_8
X$15424 VSS VDD \$5988 \$5083 \$5714 sg13g2_nor2b_1
X$15425 VDD VSS sg13g2_decap_8
X$15426 VDD VSS sg13g2_decap_8
X$15427 VDD VSS sg13g2_decap_8
X$15429 VSS \$5993 VDD CS sg13g2_buf_1
X$15430 VDD VSS sg13g2_decap_8
X$15431 VDD VSS sg13g2_decap_8
X$15434 VDD VSS sg13g2_decap_8
X$15435 \$6168 VDD VSS sg13g2_tiehi
X$15436 VDD VSS sg13g2_decap_8
X$15437 VDD VSS sg13g2_decap_4
X$15439 VDD VSS \$5932 \$6090 \$5931 \$5509 sg13g2_nor3_1
X$15440 VDD VSS \$3883 \$5899 \$5931 sg13g2_nor2_1
X$15442 VDD VSS sg13g2_decap_8
X$15443 VDD VSS sg13g2_decap_8
X$15445 VDD VSS \$5804 \$6112 \$6002 \$5509 sg13g2_nor3_1
X$15447 VDD VSS \$3883 \$5934 \$6002 sg13g2_nor2_1
X$15448 VDD VSS sg13g2_decap_8
X$15449 VDD VSS sg13g2_decap_4
X$15451 VDD VSS \$3883 \$5940 \$5938 sg13g2_nor2_1
X$15453 VDD VSS \$5807 \$5939 \$5938 \$5509 sg13g2_nor3_1
X$15454 VSS \$5668 \$3556 VDD sg13g2_buf_16
X$15456 VDD VSS sg13g2_decap_8
X$15459 VDD VSS \$5809 \$5509 \$6062 sg13g2_nor2_1
X$15460 VDD VSS sg13g2_decap_4
X$15461 \$6063 VDD VSS sg13g2_tiehi
X$15462 VDD VSS sg13g2_decap_8
X$15463 VDD VSS sg13g2_decap_8
X$15464 VDD VSS sg13g2_decap_8
X$15465 VDD VSS sg13g2_decap_8
X$15466 VDD VSS sg13g2_decap_8
X$15470 VDD VSS \$5942 \$5442 \$6031 sg13g2_nor2_1
X$15473 VDD VSS \$5944 \$5442 \$5945 sg13g2_nor2_1
X$15475 VDD VSS sg13g2_decap_4
X$15477 VSS \$6065 \$5905 \$5945 \$5753 VDD sg13g2_dfrbpq_1
X$15478 VDD VSS sg13g2_decap_8
X$15479 VDD VSS sg13g2_decap_8
X$15480 VDD VSS sg13g2_decap_8
X$15483 \$5948 VSS \$5949 VDD \$6041 \$4984 sg13g2_a21oi_1
X$15484 VDD VSS sg13g2_decap_8
X$15486 VDD VSS sg13g2_decap_4
X$15488 VSS \$5753 \$4583 VDD sg13g2_buf_16
X$15490 VSS \$6036 \$3897 \$5951 \$5916 VDD sg13g2_mux2_1
X$15491 VDD VSS sg13g2_decap_8
X$15492 VDD VSS sg13g2_decap_8
X$15493 VDD VSS sg13g2_decap_4
X$15495 \$5952 VDD VSS sg13g2_tiehi
X$15496 VDD VSS sg13g2_decap_8
X$15497 VDD VSS sg13g2_decap_8
X$15500 VDD VSS sg13g2_decap_8
X$15501 VDD VSS sg13g2_decap_8
X$15502 VDD VSS sg13g2_decap_8
X$15503 VDD VSS sg13g2_decap_8
X$15504 VDD VSS sg13g2_decap_8
X$15505 VDD VSS sg13g2_decap_8
X$15506 VDD VSS sg13g2_decap_8
X$15508 VDD VSS sg13g2_decap_8
X$15509 VDD VSS sg13g2_decap_8
X$15510 VDD VSS sg13g2_decap_8
X$15511 VDD VSS sg13g2_decap_4
X$15516 \$6132 VDD VSS sg13g2_tiehi
X$15517 VSS \$6132 \$5656 \$6052 \$5325 VDD sg13g2_dfrbpq_1
X$15519 VSS VDD \$6052 \$5228 \$5656 sg13g2_nor2b_1
X$15521 \$5228 \$6119 \$5784 VDD VSS sg13g2_or2_1
X$15522 VSS \$6099 \$5784 \$6119 \$5325 VDD sg13g2_dfrbpq_1
X$15525 \$6055 VDD VSS sg13g2_tiehi
X$15526 VSS \$6055 \$5922 \$5921 \$5433 VDD sg13g2_dfrbpq_1
X$15544 VSS VDD \$6141 \$5228 \$6142 sg13g2_nor2b_1
X$15545 VDD VSS sg13g2_decap_4
X$15546 VSS \$6057 \$5245 \$6141 \$5433 VDD sg13g2_dfrbpq_1
X$15548 VSS \$6123 VDD MOSI sg13g2_buf_1
X$15550 VSS VDD \$6059 \$5228 \$6123 sg13g2_nor2b_1
X$15551 VSS \$6150 \$5254 \$6059 \$5037 VDD sg13g2_dfrbpq_1
X$15557 VDD VSS sg13g2_decap_8
X$15558 VDD VSS sg13g2_decap_8
X$15559 VDD VSS sg13g2_decap_8
X$15560 VDD VSS sg13g2_decap_8
X$15565 VDD VSS sg13g2_decap_4
X$15569 \$6151 VDD VSS sg13g2_tiehi
X$15570 VSS \$6151 \$5660 \$5793 \$5037 VDD sg13g2_dfrbpq_1
X$15581 VDD VSS sg13g2_decap_4
X$15582 VSS MISO VDD \$6026 sg13g2_buf_1
X$15584 VDD VSS sg13g2_decap_4
X$15585 \$6154 VDD VSS sg13g2_tiehi
X$15590 VSS \$6154 \$5714 \$6102 \$5251 VDD sg13g2_dfrbpq_1
X$15596 \$5083 \$6104 \$6060 VDD VSS sg13g2_or2_1
X$15597 VSS \$6105 \$6060 \$6104 \$5251 VDD sg13g2_dfrbpq_1
X$15604 VDD VSS sg13g2_decap_4
X$15606 VSS \$6168 \$5899 \$6090 \$5668 VDD sg13g2_dfrbpq_1
X$15613 VDD VSS sg13g2_decap_4
X$15617 VSS DATA_READY VDD \$3367 sg13g2_buf_1
X$15618 \$6088 VDD VSS sg13g2_tiehi
X$15619 VSS \$6088 \$5934 \$6112 \$5668 VDD sg13g2_dfrbpq_1
X$15636 VDD VSS sg13g2_decap_4
X$15649 \$6084 VDD VSS sg13g2_tiehi
X$15653 VSS \$6084 \$5940 \$5939 \$5668 VDD sg13g2_dfrbpq_1
X$15657 VDD VSS sg13g2_decap_8
X$15660 VDD VSS sg13g2_decap_4
X$15663 VSS \$6063 \$5917 \$6062 \$5668 VDD sg13g2_dfrbpq_1
X$15666 VSS \$6026 \$3897 \$6128 \$5917 VDD sg13g2_mux2_1
X$15671 VDD VSS sg13g2_decap_8
X$15674 VDD VSS sg13g2_decap_8
X$15684 \$6065 VDD VSS sg13g2_tiehi
X$15686 \$6066 VDD VSS sg13g2_tiehi
X$15689 VSS \$6066 \$5916 \$6031 \$5753 VDD sg13g2_dfrbpq_1
X$15693 VDD VSS sg13g2_decap_8
X$15695 \$6067 VDD VSS sg13g2_tiehi
X$15696 VSS \$6067 \$6128 \$5948 \$5753 VDD sg13g2_dfrbpq_1
X$15709 VDD VSS sg13g2_decap_8
X$15710 VDD VSS sg13g2_decap_4
X$15715 VDD VSS \$5907 \$5951 \$4948 sg13g2_nand2_1
X$15717 \$6185 VDD VSS sg13g2_tiehi
X$15718 VSS \$6185 \$5951 \$6044 \$5753 VDD sg13g2_dfrbpq_1
X$15728 VDD VSS sg13g2_decap_8
X$15730 VDD VSS sg13g2_decap_8
X$15731 VDD VSS sg13g2_decap_4
X$15736 \$6189 VDD VSS sg13g2_tiehi
X$15737 VSS \$6189 \$5842 \$5822 \$5047 VDD sg13g2_dfrbpq_1
X$15738 VDD VSS sg13g2_decap_8
X$15739 VDD VSS sg13g2_decap_8
X$15740 VDD VSS sg13g2_decap_4
X$15741 VDD VSS sg13g2_decap_8
X$15742 VDD VSS sg13g2_decap_8
X$15743 VDD VSS sg13g2_decap_8
X$15744 VDD VSS sg13g2_decap_8
X$15747 VDD VSS sg13g2_decap_8
X$15752 VDD VSS sg13g2_decap_8
X$15755 VDD VSS sg13g2_decap_8
X$15757 VDD VSS sg13g2_decap_8
X$15758 VDD VSS sg13g2_decap_8
X$15763 VDD VSS sg13g2_decap_8
X$15772 VDD VSS sg13g2_decap_8
X$15775 VDD VSS sg13g2_decap_8
X$15777 VDD VSS sg13g2_decap_8
X$15778 VDD VSS sg13g2_decap_8
X$15781 VDD VSS sg13g2_decap_8
X$15786 VSS \$6142 VDD SCK sg13g2_buf_1
X$15789 VDD VSS sg13g2_decap_8
X$15792 VDD VSS sg13g2_decap_8
X$15793 VDD VSS sg13g2_decap_8
X$15798 VDD VSS sg13g2_decap_8
X$15804 VDD VSS sg13g2_decap_8
X$15808 VDD VSS sg13g2_decap_8
X$15809 VDD VSS sg13g2_decap_8
X$15812 VDD VSS sg13g2_decap_8
X$15814 VDD VSS sg13g2_decap_8
X$15818 VDD VSS sg13g2_decap_8
X$15823 VDD VSS sg13g2_decap_8
X$15827 VDD VSS sg13g2_decap_8
X$15829 VDD VSS sg13g2_decap_8
X$15830 VDD VSS sg13g2_decap_8
X$15832 VDD VSS sg13g2_decap_8
X$15833 VDD VSS sg13g2_decap_8
X$15834 VDD VSS sg13g2_decap_8
X$15835 VDD VSS sg13g2_decap_8
X$15836 VDD VSS sg13g2_decap_8
X$15840 VDD VSS sg13g2_decap_8
X$15843 VDD VSS sg13g2_decap_8
X$15845 VDD VSS sg13g2_decap_8
X$15846 VDD VSS sg13g2_decap_8
X$15848 VDD VSS sg13g2_decap_8
X$15851 VDD VSS sg13g2_decap_8
X$15855 VDD VSS sg13g2_decap_8
X$15858 VDD VSS sg13g2_decap_8
X$15861 VDD VSS sg13g2_decap_8
X$15863 VDD VSS sg13g2_decap_8
X$15872 \$6105 VDD VSS sg13g2_tiehi
X$15874 VDD VSS sg13g2_decap_8
X$15876 VDD VSS sg13g2_decap_8
X$15878 VDD VSS sg13g2_decap_8
X$15881 VDD VSS sg13g2_decap_8
X$15884 VDD VSS sg13g2_decap_8
X$15888 VDD VSS sg13g2_decap_8
X$15891 VDD VSS sg13g2_decap_8
X$15892 VDD VSS sg13g2_decap_8
X$15895 VDD VSS sg13g2_decap_8
X$15899 VDD VSS sg13g2_decap_8
X$15904 VDD VSS sg13g2_decap_8
X$15909 VDD VSS sg13g2_decap_8
X$15912 VDD VSS sg13g2_decap_8
X$15913 VDD VSS sg13g2_decap_8
X$15915 VDD VSS sg13g2_decap_8
X$15919 VDD VSS sg13g2_decap_8
X$15922 VDD VSS sg13g2_decap_8
X$15925 VDD VSS sg13g2_decap_8
X$15926 VDD VSS sg13g2_decap_8
X$15928 VDD VSS sg13g2_decap_8
X$15929 VDD VSS sg13g2_decap_8
X$15932 VDD VSS sg13g2_decap_8
X$15933 VDD VSS sg13g2_decap_8
X$15936 VDD VSS sg13g2_decap_8
X$15938 VDD VSS sg13g2_decap_8
X$15943 VDD VSS sg13g2_decap_8
X$15947 VDD VSS sg13g2_decap_8
X$15948 VDD VSS sg13g2_decap_8
X$15949 VDD VSS sg13g2_decap_8
X$15952 VDD VSS sg13g2_decap_8
X$15956 VDD VSS sg13g2_decap_8
X$15959 VDD VSS sg13g2_decap_8
X$15960 VDD VSS sg13g2_decap_8
X$15962 VDD VSS sg13g2_decap_8
X$15963 VDD VSS sg13g2_decap_8
X$15966 VDD VSS sg13g2_decap_4
X$15968 VDD VSS \$5949 \$6128 \$4948 sg13g2_nand2_1
X$15970 VDD VSS sg13g2_decap_8
X$15973 VDD VSS sg13g2_decap_8
X$15975 VDD VSS sg13g2_decap_8
X$15978 VDD VSS sg13g2_decap_8
X$15980 VDD VSS sg13g2_decap_8
X$15986 VDD VSS sg13g2_decap_8
X$15993 VDD VSS sg13g2_decap_8
X$15994 VDD VSS sg13g2_decap_8
X$15996 VDD VSS sg13g2_decap_8
X$15998 VDD VSS sg13g2_decap_8
X$15999 VDD VSS sg13g2_decap_8
X$16000 VDD VSS sg13g2_decap_8
X$16003 VDD VSS sg13g2_decap_8
X$16007 VDD VSS sg13g2_decap_8
X$16010 VDD VSS sg13g2_decap_8
X$16012 VDD VSS sg13g2_decap_8
X$16013 VDD VSS sg13g2_decap_8
X$16015 VDD VSS sg13g2_decap_8
X$16016 VDD VSS sg13g2_decap_4
.ENDS digital_block_top

.SUBCKT sg13g2_inv_8 VSS Y A VDD
M$1 VSS A Y VSS sg13_lv_nmos L=0.13u W=5.92u AS=1.2395p AD=1.2395p PS=10.01u
+ PD=10.01u
M$9 VDD A Y VDD sg13_lv_pmos L=0.13u W=8.96u AS=1.876p AD=1.876p PS=13.43u
+ PD=13.43u
.ENDS sg13g2_inv_8

.SUBCKT sg13g2_nand2b_2 VDD VSS Y B A_N
M$1 \$3 \$6 VSS VSS sg13_lv_nmos L=0.13u W=1.44u AS=0.396p AD=0.2772p PS=3.26u
+ PD=2.21u
M$3 \$3 B Y VSS sg13_lv_nmos L=0.13u W=1.44u AS=0.2772p AD=0.3816p PS=2.21u
+ PD=3.22u
M$5 VSS A_N \$6 VSS sg13_lv_nmos L=0.13u W=0.55u AS=0.187p AD=0.187p PS=1.78u
+ PD=1.78u
M$6 VDD \$6 Y VDD sg13_lv_pmos L=0.13u W=2.24u AS=0.616p AD=0.4312p PS=4.46u
+ PD=3.01u
M$8 VDD B Y VDD sg13_lv_pmos L=0.13u W=2.24u AS=0.4312p AD=0.6048p PS=3.01u
+ PD=4.44u
M$10 VDD A_N \$6 VDD sg13_lv_pmos L=0.13u W=0.84u AS=0.2856p AD=0.2856p
+ PS=2.36u PD=2.36u
.ENDS sg13g2_nand2b_2

.SUBCKT sg13g2_a21oi_2 VDD VSS Y A2 B1 A1
M$1 VSS A2 \$2 VSS sg13_lv_nmos L=0.13u W=1.48u AS=0.3922p AD=0.2812p PS=3.28u
+ PD=2.24u
M$2 \$2 A1 Y VSS sg13_lv_nmos L=0.13u W=1.48u AS=0.2812p AD=0.2812p PS=2.24u
+ PD=2.24u
M$5 VSS B1 Y VSS sg13_lv_nmos L=0.13u W=1.48u AS=0.2812p AD=0.3922p PS=2.24u
+ PD=3.28u
M$7 \$4 A2 VDD VDD sg13_lv_pmos L=0.13u W=2.24u AS=0.5936p AD=0.4256p PS=4.42u
+ PD=3u
M$8 VDD A1 \$4 VDD sg13_lv_pmos L=0.13u W=2.24u AS=0.4256p AD=0.4256p PS=3u
+ PD=3u
M$11 \$4 B1 Y VDD sg13_lv_pmos L=0.13u W=2.24u AS=0.4256p AD=0.5936p PS=3u
+ PD=4.42u
.ENDS sg13g2_a21oi_2

.SUBCKT sg13g2_mux2_2 VSS X S A1 A0 VDD
M$1 VSS S \$4 VSS sg13_lv_nmos L=0.13u W=0.55u AS=0.18945p AD=0.187p PS=1.27u
+ PD=1.78u
M$2 VSS S \$8 VSS sg13_lv_nmos L=0.13u W=0.74u AS=0.18945p AD=0.13135p PS=1.27u
+ PD=1.095u
M$3 \$8 A1 \$2 VSS sg13_lv_nmos L=0.13u W=0.74u AS=0.13135p AD=0.1628p
+ PS=1.095u PD=1.18u
M$4 \$2 A0 \$9 VSS sg13_lv_nmos L=0.13u W=0.74u AS=0.1628p AD=0.3367p PS=1.18u
+ PD=1.65u
M$5 \$9 \$4 VSS VSS sg13_lv_nmos L=0.13u W=0.74u AS=0.3367p AD=0.148p PS=1.65u
+ PD=1.14u
M$6 VSS \$2 X VSS sg13_lv_nmos L=0.13u W=1.48u AS=0.3515p AD=0.518p PS=2.43u
+ PD=3.62u
M$8 \$4 S VDD VDD sg13_lv_pmos L=0.13u W=0.84u AS=0.2856p AD=0.253p PS=2.36u
+ PD=1.53u
M$9 VDD S \$11 VDD sg13_lv_pmos L=0.13u W=1u AS=0.253p AD=0.3325p PS=1.53u
+ PD=1.665u
M$10 \$11 A0 \$2 VDD sg13_lv_pmos L=0.13u W=1u AS=0.3325p AD=0.2225p PS=1.665u
+ PD=1.445u
M$11 \$2 A1 \$12 VDD sg13_lv_pmos L=0.13u W=1u AS=0.2225p AD=0.2975p PS=1.445u
+ PD=1.595u
M$12 \$12 \$4 VDD VDD sg13_lv_pmos L=0.13u W=1u AS=0.2975p AD=0.2198p PS=1.595u
+ PD=1.52u
M$13 VDD \$2 X VDD sg13_lv_pmos L=0.13u W=2.24u AS=0.5278p AD=0.784p PS=3.19u
+ PD=4.76u
.ENDS sg13g2_mux2_2

.SUBCKT sg13g2_nor2_2 VSS Y A B VDD
M$1 VSS A Y VSS sg13_lv_nmos L=0.13u W=1.48u AS=0.3922p AD=0.2812p PS=3.28u
+ PD=2.24u
M$3 VSS B Y VSS sg13_lv_nmos L=0.13u W=1.48u AS=0.2812p AD=0.3922p PS=2.24u
+ PD=3.28u
M$5 \$5 A VDD VDD sg13_lv_pmos L=0.13u W=2.24u AS=0.616p AD=0.4256p PS=4.46u
+ PD=3u
M$7 \$5 B Y VDD sg13_lv_pmos L=0.13u W=2.24u AS=0.4256p AD=0.5936p PS=3u
+ PD=4.42u
.ENDS sg13g2_nor2_2

.SUBCKT sg13g2_or3_1 VDD VSS C A B X
M$1 \$6 C VSS VSS sg13_lv_nmos L=0.13u W=0.55u AS=0.187p AD=0.1045p PS=1.78u
+ PD=0.93u
M$2 VSS B \$6 VSS sg13_lv_nmos L=0.13u W=0.55u AS=0.1045p AD=0.198p PS=0.93u
+ PD=1.27u
M$3 \$6 A VSS VSS sg13_lv_nmos L=0.13u W=0.55u AS=0.198p AD=0.13395p PS=1.27u
+ PD=1.12u
M$4 VSS \$6 X VSS sg13_lv_nmos L=0.13u W=0.74u AS=0.13395p AD=0.2516p PS=1.12u
+ PD=2.16u
M$5 \$6 C \$9 VDD sg13_lv_pmos L=0.13u W=1u AS=0.34p AD=0.19p PS=2.68u PD=1.38u
M$6 \$9 B \$8 VDD sg13_lv_pmos L=0.13u W=1u AS=0.19p AD=0.1575p PS=1.38u
+ PD=1.315u
M$7 \$8 A VDD VDD sg13_lv_pmos L=0.13u W=1u AS=0.1575p AD=0.3822p PS=1.315u
+ PD=1.84u
M$8 VDD \$6 X VDD sg13_lv_pmos L=0.13u W=1.12u AS=0.3822p AD=0.3808p PS=1.84u
+ PD=2.92u
.ENDS sg13g2_or3_1

.SUBCKT sg13g2_nor3_2 A VDD VSS Y C B
M$1 VSS A Y VSS sg13_lv_nmos L=0.13u W=1.48u AS=0.3959p AD=0.4699p PS=3.29u
+ PD=2.75u
M$3 VSS B Y VSS sg13_lv_nmos L=0.13u W=1.48u AS=0.4699p AD=0.2812p PS=2.75u
+ PD=2.24u
M$5 VSS C Y VSS sg13_lv_nmos L=0.13u W=1.48u AS=0.2812p AD=0.3922p PS=2.24u
+ PD=3.28u
M$7 \$5 B \$1 VDD sg13_lv_pmos L=0.13u W=2.24u AS=0.5936p AD=0.4256p PS=4.42u
+ PD=3u
M$9 \$5 C Y VDD sg13_lv_pmos L=0.13u W=2.24u AS=0.4256p AD=0.5936p PS=3u
+ PD=4.42u
M$11 VDD A \$1 VDD sg13_lv_pmos L=0.13u W=2.24u AS=0.5992p AD=0.5936p PS=4.43u
+ PD=4.42u
.ENDS sg13g2_nor3_2

.SUBCKT sg13g2_nand2_2 A Y B VDD VSS
M$1 \$4 B VSS VSS sg13_lv_nmos L=0.13u W=1.44u AS=0.4068p AD=0.2772p PS=3.29u
+ PD=2.21u
M$3 \$4 A Y VSS sg13_lv_nmos L=0.13u W=1.44u AS=0.2772p AD=0.3816p PS=2.21u
+ PD=3.22u
M$5 VDD B Y VDD sg13_lv_pmos L=0.13u W=2.24u AS=0.616p AD=0.4312p PS=4.46u
+ PD=3.01u
M$7 VDD A Y VDD sg13_lv_pmos L=0.13u W=2.24u AS=0.4312p AD=0.6048p PS=3.01u
+ PD=4.44u
.ENDS sg13g2_nand2_2

.SUBCKT sg13g2_nor4_2 VSS Y A B C D VDD
M$1 VSS A Y VSS sg13_lv_nmos L=0.13u W=1.48u AS=0.3959p AD=0.4699p PS=3.29u
+ PD=2.75u
M$3 VSS B Y VSS sg13_lv_nmos L=0.13u W=1.48u AS=0.4699p AD=0.2812p PS=2.75u
+ PD=2.24u
M$5 VSS C Y VSS sg13_lv_nmos L=0.13u W=1.48u AS=0.2812p AD=0.4699p PS=2.24u
+ PD=2.75u
M$7 VSS D Y VSS sg13_lv_nmos L=0.13u W=1.48u AS=0.4699p AD=0.3922p PS=2.75u
+ PD=3.28u
M$9 \$10 D Y VDD sg13_lv_pmos L=0.13u W=2.24u AS=0.5936p AD=0.5936p PS=4.42u
+ PD=4.42u
M$11 \$9 B \$8 VDD sg13_lv_pmos L=0.13u W=2.24u AS=0.5936p AD=0.4256p PS=4.42u
+ PD=3u
M$13 \$9 C \$10 VDD sg13_lv_pmos L=0.13u W=2.24u AS=0.4256p AD=0.5936p PS=3u
+ PD=4.42u
M$15 VDD A \$8 VDD sg13_lv_pmos L=0.13u W=2.24u AS=0.5992p AD=0.5936p PS=4.43u
+ PD=4.42u
.ENDS sg13g2_nor4_2

.SUBCKT sg13g2_a21o_1 VDD VSS X B1 A1 A2
M$1 X \$6 VSS VSS sg13_lv_nmos L=0.13u W=0.74u AS=0.2351p AD=0.15745p PS=2.16u
+ PD=1.175u
M$2 VSS B1 \$6 VSS sg13_lv_nmos L=0.13u W=0.64u AS=0.15745p AD=0.1216p
+ PS=1.175u PD=1.02u
M$3 \$6 A1 \$9 VSS sg13_lv_nmos L=0.13u W=0.64u AS=0.1216p AD=0.0816p PS=1.02u
+ PD=0.895u
M$4 \$9 A2 VSS VSS sg13_lv_nmos L=0.13u W=0.64u AS=0.0816p AD=0.2176p PS=0.895u
+ PD=1.96u
M$5 \$6 B1 \$5 VDD sg13_lv_pmos L=0.13u W=1u AS=0.35p AD=0.2125p PS=2.7u
+ PD=1.425u
M$6 \$5 A1 VDD VDD sg13_lv_pmos L=0.13u W=1u AS=0.2125p AD=0.19p PS=1.425u
+ PD=1.38u
M$7 VDD A2 \$5 VDD sg13_lv_pmos L=0.13u W=1u AS=0.19p AD=0.34p PS=1.38u PD=2.68u
M$8 X \$6 VDD VDD sg13_lv_pmos L=0.13u W=1.12u AS=0.3808p AD=0.3808p PS=2.92u
+ PD=2.92u
.ENDS sg13g2_a21o_1

.SUBCKT sg13g2_or2_1 A X B VDD VSS
M$1 VSS B \$6 VSS sg13_lv_nmos L=0.13u W=0.55u AS=0.187p AD=0.1045p PS=1.78u
+ PD=0.93u
M$2 \$6 A VSS VSS sg13_lv_nmos L=0.13u W=0.55u AS=0.1045p AD=0.1469p PS=0.93u
+ PD=1.155u
M$3 VSS \$6 X VSS sg13_lv_nmos L=0.13u W=0.74u AS=0.1469p AD=0.2516p PS=1.155u
+ PD=2.16u
M$4 \$6 B \$7 VDD sg13_lv_pmos L=0.13u W=0.84u AS=0.2856p AD=0.1596p PS=2.36u
+ PD=1.22u
M$5 VDD A \$7 VDD sg13_lv_pmos L=0.13u W=0.84u AS=0.2226p AD=0.1596p PS=1.535u
+ PD=1.22u
M$6 VDD \$6 X VDD sg13_lv_pmos L=0.13u W=1.12u AS=0.2226p AD=0.3976p PS=1.535u
+ PD=2.95u
.ENDS sg13g2_or2_1

.SUBCKT sg13g2_mux4_1 VSS S1 X S0 A0 A1 A2 A3 VDD
M$1 \$3 S1 \$12 VSS sg13_lv_nmos L=0.13u W=0.64u AS=0.541875p AD=0.1216p
+ PS=3.42u PD=1.02u
M$2 \$12 \$13 \$5 VSS sg13_lv_nmos L=0.13u W=0.64u AS=0.1216p AD=0.2176p
+ PS=1.02u PD=1.96u
M$3 VSS S1 \$13 VSS sg13_lv_nmos L=0.13u W=0.64u AS=0.1543p AD=0.2304p PS=1.18u
+ PD=2u
M$4 VSS \$12 X VSS sg13_lv_nmos L=0.13u W=0.74u AS=0.1543p AD=0.2516p PS=1.18u
+ PD=2.16u
M$5 \$2 S0 VSS VSS sg13_lv_nmos L=0.13u W=0.64u AS=0.2176p AD=0.1872p PS=1.96u
+ PD=1.225u
M$6 VSS A0 \$14 VSS sg13_lv_nmos L=0.13u W=0.64u AS=0.1872p AD=0.0768p
+ PS=1.225u PD=0.88u
M$7 \$14 \$2 \$5 VSS sg13_lv_nmos L=0.13u W=0.64u AS=0.0768p AD=0.1472p
+ PS=0.88u PD=1.1u
M$8 \$5 S0 \$15 VSS sg13_lv_nmos L=0.13u W=0.64u AS=0.1472p AD=0.2304p PS=1.1u
+ PD=1.36u
M$9 \$15 A1 VSS VSS sg13_lv_nmos L=0.13u W=0.64u AS=0.2304p AD=0.1824p PS=1.36u
+ PD=1.21u
M$10 VSS A2 \$16 VSS sg13_lv_nmos L=0.13u W=0.64u AS=0.1824p AD=0.08p PS=1.21u
+ PD=0.89u
M$11 \$16 \$2 \$3 VSS sg13_lv_nmos L=0.13u W=0.64u AS=0.08p AD=0.1776p PS=0.89u
+ PD=1.195u
M$12 \$3 S0 \$17 VSS sg13_lv_nmos L=0.13u W=0.64u AS=0.1776p AD=0.0768p
+ PS=1.195u PD=0.88u
M$13 \$17 A3 VSS VSS sg13_lv_nmos L=0.13u W=0.64u AS=0.0768p AD=0.2176p
+ PS=0.88u PD=1.96u
M$14 VDD S1 \$13 VDD sg13_lv_pmos L=0.13u W=1u AS=0.343675p AD=0.34p PS=1.775u
+ PD=2.68u
M$15 VDD \$12 X VDD sg13_lv_pmos L=0.13u W=1.12u AS=0.343675p AD=0.3808p
+ PS=1.775u PD=2.92u
M$16 VDD A0 \$19 VDD sg13_lv_pmos L=0.13u W=1u AS=0.2231625p AD=0.415p
+ PS=1.555u PD=1.83u
M$17 \$19 S0 \$5 VDD sg13_lv_pmos L=0.13u W=1u AS=0.415p AD=0.19p PS=1.83u
+ PD=1.38u
M$18 \$5 \$2 \$20 VDD sg13_lv_pmos L=0.13u W=1u AS=0.19p AD=0.16p PS=1.38u
+ PD=1.32u
M$19 \$20 A1 VDD VDD sg13_lv_pmos L=0.13u W=1u AS=0.16p AD=0.29275p PS=1.32u
+ PD=1.785u
M$20 VDD A2 \$21 VDD sg13_lv_pmos L=0.13u W=1u AS=0.29275p AD=0.207625p
+ PS=1.785u PD=1.605u
M$21 VDD S0 \$2 VDD sg13_lv_pmos L=0.13u W=1u AS=0.2231625p AD=0.34p PS=1.555u
+ PD=2.68u
M$22 \$21 S0 \$3 VDD sg13_lv_pmos L=0.13u W=1u AS=0.207625p AD=0.4425p
+ PS=1.605u PD=1.885u
M$23 \$3 \$2 \$22 VDD sg13_lv_pmos L=0.13u W=1u AS=0.4425p AD=0.135p PS=1.885u
+ PD=1.27u
M$24 \$22 A3 VDD VDD sg13_lv_pmos L=0.13u W=1u AS=0.135p AD=0.34p PS=1.27u
+ PD=2.68u
M$25 \$5 S1 \$12 VDD sg13_lv_pmos L=0.13u W=1u AS=0.34p AD=0.2225p PS=2.68u
+ PD=1.445u
M$26 \$12 \$13 \$3 VDD sg13_lv_pmos L=0.13u W=1u AS=0.2225p AD=0.34p PS=1.445u
+ PD=2.68u
.ENDS sg13g2_mux4_1

.SUBCKT sg13g2_or4_1 VDD VSS B D A C X
M$1 VSS D \$7 VSS sg13_lv_nmos L=0.13u W=0.55u AS=0.187p AD=0.1045p PS=1.78u
+ PD=0.93u
M$2 VSS C \$7 VSS sg13_lv_nmos L=0.13u W=0.55u AS=0.16755p AD=0.1045p PS=1.165u
+ PD=0.93u
M$3 VSS B \$7 VSS sg13_lv_nmos L=0.13u W=0.55u AS=0.16755p AD=0.1045p PS=1.165u
+ PD=0.93u
M$4 VSS A \$7 VSS sg13_lv_nmos L=0.13u W=0.55u AS=0.14135p AD=0.1045p PS=1.14u
+ PD=0.93u
M$5 VSS \$7 X VSS sg13_lv_nmos L=0.13u W=0.74u AS=0.14135p AD=0.2516p PS=1.14u
+ PD=2.16u
M$6 \$7 D \$11 VDD sg13_lv_pmos L=0.13u W=1u AS=0.34p AD=0.19p PS=2.68u PD=1.38u
M$7 \$11 C \$10 VDD sg13_lv_pmos L=0.13u W=1u AS=0.19p AD=0.2925p PS=1.38u
+ PD=1.585u
M$8 \$10 B \$9 VDD sg13_lv_pmos L=0.13u W=1u AS=0.2925p AD=0.19p PS=1.585u
+ PD=1.38u
M$9 VDD A \$9 VDD sg13_lv_pmos L=0.13u W=1u AS=0.2144p AD=0.19p PS=1.52u
+ PD=1.38u
M$10 VDD \$7 X VDD sg13_lv_pmos L=0.13u W=1.12u AS=0.2144p AD=0.3808p PS=1.52u
+ PD=2.92u
.ENDS sg13g2_or4_1

.SUBCKT sg13g2_and3_1 VDD VSS A C B X
M$1 \$7 A \$9 VSS sg13_lv_nmos L=0.13u W=0.64u AS=0.2176p AD=0.1216p PS=1.96u
+ PD=1.02u
M$2 \$9 B \$8 VSS sg13_lv_nmos L=0.13u W=0.64u AS=0.1216p AD=0.1216p PS=1.02u
+ PD=1.02u
M$3 VSS C \$8 VSS sg13_lv_nmos L=0.13u W=0.64u AS=0.1371p AD=0.1216p PS=1.12u
+ PD=1.02u
M$4 VSS \$7 X VSS sg13_lv_nmos L=0.13u W=0.74u AS=0.1371p AD=0.2516p PS=1.12u
+ PD=2.16u
M$5 \$7 A VDD VDD sg13_lv_pmos L=0.13u W=0.84u AS=0.2856p AD=0.1596p PS=2.36u
+ PD=1.22u
M$6 VDD B \$7 VDD sg13_lv_pmos L=0.13u W=0.84u AS=0.1596p AD=0.1596p PS=1.22u
+ PD=1.22u
M$7 VDD C \$7 VDD sg13_lv_pmos L=0.13u W=0.84u AS=0.36195p AD=0.1596p PS=1.84u
+ PD=1.22u
M$8 VDD \$7 X VDD sg13_lv_pmos L=0.13u W=1.12u AS=0.36195p AD=0.3808p PS=1.84u
+ PD=2.92u
.ENDS sg13g2_and3_1

.SUBCKT sg13g2_nand3b_1 VDD VSS Y B C A_N
M$1 VSS A_N \$6 VSS sg13_lv_nmos L=0.13u W=0.55u AS=0.18575p AD=0.187p PS=1.26u
+ PD=1.78u
M$2 VSS C \$9 VSS sg13_lv_nmos L=0.13u W=0.74u AS=0.18575p AD=0.1406p PS=1.26u
+ PD=1.12u
M$3 \$9 B \$8 VSS sg13_lv_nmos L=0.13u W=0.74u AS=0.1406p AD=0.1406p PS=1.12u
+ PD=1.12u
M$4 \$8 \$6 Y VSS sg13_lv_nmos L=0.13u W=0.74u AS=0.1406p AD=0.3404p PS=1.12u
+ PD=2.4u
M$5 \$6 A_N VDD VDD sg13_lv_pmos L=0.13u W=0.84u AS=0.2856p AD=0.2198p PS=2.36u
+ PD=1.53u
M$6 VDD C Y VDD sg13_lv_pmos L=0.13u W=1.12u AS=0.2198p AD=0.2128p PS=1.53u
+ PD=1.5u
M$7 Y B VDD VDD sg13_lv_pmos L=0.13u W=1.12u AS=0.2128p AD=0.2128p PS=1.5u
+ PD=1.5u
M$8 VDD \$6 Y VDD sg13_lv_pmos L=0.13u W=1.12u AS=0.2128p AD=0.3808p PS=1.5u
+ PD=2.92u
.ENDS sg13g2_nand3b_1

.SUBCKT sg13g2_a22oi_1 Y VSS VDD A2 B2 B1 A1
M$1 VSS B1 \$10 VSS sg13_lv_nmos L=0.13u W=0.74u AS=0.2553p AD=0.13875p
+ PS=2.17u PD=1.115u
M$2 \$10 B2 Y VSS sg13_lv_nmos L=0.13u W=0.74u AS=0.13875p AD=0.2664p PS=1.115u
+ PD=1.46u
M$3 Y A1 \$9 VSS sg13_lv_nmos L=0.13u W=0.74u AS=0.2664p AD=0.0962p PS=1.46u
+ PD=1u
M$4 \$9 A2 VSS VSS sg13_lv_nmos L=0.13u W=0.74u AS=0.0962p AD=0.2516p PS=1u
+ PD=2.16u
M$5 VDD A1 \$5 VDD sg13_lv_pmos L=0.13u W=1.12u AS=0.3808p AD=0.2716p PS=2.92u
+ PD=1.605u
M$6 \$5 B1 Y VDD sg13_lv_pmos L=0.13u W=1.12u AS=0.2716p AD=0.2128p PS=1.605u
+ PD=1.5u
M$7 Y B2 \$5 VDD sg13_lv_pmos L=0.13u W=1.12u AS=0.2128p AD=0.2744p PS=1.5u
+ PD=1.61u
M$8 \$5 A2 VDD VDD sg13_lv_pmos L=0.13u W=1.12u AS=0.2744p AD=0.3808p PS=1.61u
+ PD=2.92u
.ENDS sg13g2_a22oi_1

.SUBCKT sg13g2_buf_8 VSS A VDD
M$1 \$2 A VSS VSS sg13_lv_nmos L=0.13u W=2.22u AS=0.5365p AD=0.4218p PS=4.41u
+ PD=3.36u
M$4 VSS \$2 X VSS sg13_lv_nmos L=0.13u W=5.92u AS=1.1248p AD=1.2358p PS=8.96u
+ PD=10u
M$12 \$2 A VDD VDD sg13_lv_pmos L=0.13u W=3.36u AS=0.8064p AD=0.6384p PS=5.92u
+ PD=4.5u
M$15 VDD \$2 X VDD sg13_lv_pmos L=0.13u W=8.96u AS=1.7024p AD=1.876p PS=12u
+ PD=13.43u
.ENDS sg13g2_buf_8

.SUBCKT sg13g2_and4_1 VSS VDD X D C B A
M$1 \$4 A \$11 VSS sg13_lv_nmos L=0.13u W=0.64u AS=0.2176p AD=0.1216p PS=1.96u
+ PD=1.02u
M$2 \$11 B \$10 VSS sg13_lv_nmos L=0.13u W=0.64u AS=0.1216p AD=0.1216p PS=1.02u
+ PD=1.02u
M$3 \$10 C \$9 VSS sg13_lv_nmos L=0.13u W=0.64u AS=0.1216p AD=0.1408p PS=1.02u
+ PD=1.08u
M$4 \$9 D VSS VSS sg13_lv_nmos L=0.13u W=0.64u AS=0.1408p AD=0.1447p PS=1.08u
+ PD=1.15u
M$5 VSS \$4 X VSS sg13_lv_nmos L=0.13u W=0.74u AS=0.1447p AD=0.3552p PS=1.15u
+ PD=2.44u
M$6 VDD A \$4 VDD sg13_lv_pmos L=0.13u W=0.84u AS=0.2856p AD=0.1596p PS=2.36u
+ PD=1.22u
M$7 \$4 B VDD VDD sg13_lv_pmos L=0.13u W=0.84u AS=0.1596p AD=0.1596p PS=1.22u
+ PD=1.22u
M$8 VDD C \$4 VDD sg13_lv_pmos L=0.13u W=0.84u AS=0.1596p AD=0.1848p PS=1.22u
+ PD=1.28u
M$9 VDD D \$4 VDD sg13_lv_pmos L=0.13u W=0.84u AS=0.2044p AD=0.1848p PS=1.53u
+ PD=1.28u
M$10 VDD \$4 X VDD sg13_lv_pmos L=0.13u W=1.12u AS=0.2044p AD=0.5376p PS=1.53u
+ PD=3.2u
.ENDS sg13g2_and4_1

.SUBCKT sg13g2_a221oi_1 VSS B1 VDD Y B2 C1 A1 A2
M$1 Y A1 \$11 VSS sg13_lv_nmos L=0.13u W=0.74u AS=0.2516p AD=0.1406p PS=2.16u
+ PD=1.12u
M$2 \$11 A2 VSS VSS sg13_lv_nmos L=0.13u W=0.74u AS=0.1406p AD=0.2516p PS=1.12u
+ PD=2.16u
M$3 Y C1 VSS VSS sg13_lv_nmos L=0.13u W=0.74u AS=0.2516p AD=0.1406p PS=2.16u
+ PD=1.12u
M$4 VSS B2 \$12 VSS sg13_lv_nmos L=0.13u W=0.74u AS=0.1406p AD=0.1406p PS=1.12u
+ PD=1.12u
M$5 \$12 B1 Y VSS sg13_lv_nmos L=0.13u W=0.74u AS=0.1406p AD=0.2516p PS=1.12u
+ PD=2.16u
M$6 VDD A1 \$9 VDD sg13_lv_pmos L=0.13u W=1.12u AS=0.3808p AD=0.2128p PS=2.92u
+ PD=1.5u
M$7 \$9 A2 VDD VDD sg13_lv_pmos L=0.13u W=1.12u AS=0.2128p AD=0.3808p PS=1.5u
+ PD=2.92u
M$8 Y C1 \$6 VDD sg13_lv_pmos L=0.13u W=1.12u AS=0.3808p AD=0.2128p PS=2.92u
+ PD=1.5u
M$9 \$6 B2 \$9 VDD sg13_lv_pmos L=0.13u W=1.12u AS=0.2128p AD=0.2128p PS=1.5u
+ PD=1.5u
M$10 \$9 B1 \$6 VDD sg13_lv_pmos L=0.13u W=1.12u AS=0.2128p AD=0.3808p PS=1.5u
+ PD=2.92u
.ENDS sg13g2_a221oi_1

.SUBCKT sg13g2_inv_2 A Y VSS VDD
M$1 VSS A Y VSS sg13_lv_nmos L=0.13u W=1.48u AS=0.3922p AD=0.3922p PS=3.28u
+ PD=3.28u
M$3 VDD A Y VDD sg13_lv_pmos L=0.13u W=2.24u AS=0.5936p AD=0.5992p PS=4.42u
+ PD=4.43u
.ENDS sg13g2_inv_2

.SUBCKT sg13g2_nor2b_1 VSS VDD Y A B_N
M$1 VSS B_N \$5 VSS sg13_lv_nmos L=0.13u W=0.55u AS=0.17255p AD=0.187p PS=1.25u
+ PD=1.78u
M$2 VSS \$5 Y VSS sg13_lv_nmos L=0.13u W=0.74u AS=0.17255p AD=0.1406p PS=1.25u
+ PD=1.12u
M$3 Y A VSS VSS sg13_lv_nmos L=0.13u W=0.74u AS=0.1406p AD=0.2516p PS=1.12u
+ PD=2.16u
M$4 \$5 B_N VDD VDD sg13_lv_pmos L=0.13u W=0.84u AS=0.2856p AD=0.2618p PS=2.36u
+ PD=1.63u
M$5 VDD \$5 \$7 VDD sg13_lv_pmos L=0.13u W=1.12u AS=0.2618p AD=0.1176p PS=1.63u
+ PD=1.33u
M$6 \$7 A Y VDD sg13_lv_pmos L=0.13u W=1.12u AS=0.1176p AD=0.3808p PS=1.33u
+ PD=2.92u
.ENDS sg13g2_nor2b_1

.SUBCKT sg13g2_inv_1 VDD VSS A Y
M$1 VSS A Y VSS sg13_lv_nmos L=0.13u W=0.74u AS=0.2516p AD=0.2516p PS=2.16u
+ PD=2.16u
M$2 VDD A Y VDD sg13_lv_pmos L=0.13u W=1.12u AS=0.3808p AD=0.3808p PS=2.92u
+ PD=2.92u
.ENDS sg13g2_inv_1

.SUBCKT sg13g2_buf_1 VSS X VDD A
M$1 VSS A \$1 VSS sg13_lv_nmos L=0.13u W=0.55u AS=0.14875p AD=0.187p PS=1.16u
+ PD=1.78u
M$2 VSS \$1 X VSS sg13_lv_nmos L=0.13u W=0.74u AS=0.14875p AD=0.2886p PS=1.16u
+ PD=2.26u
M$3 VDD A \$1 VDD sg13_lv_pmos L=0.13u W=0.84u AS=0.2114p AD=0.2856p PS=1.54u
+ PD=2.36u
M$4 VDD \$1 X VDD sg13_lv_pmos L=0.13u W=1.12u AS=0.2114p AD=0.42p PS=1.54u
+ PD=2.99u
.ENDS sg13g2_buf_1

.SUBCKT sg13g2_inv_4 VDD VSS A Y
M$1 VSS A Y VSS sg13_lv_nmos L=0.13u W=2.96u AS=0.6734p AD=0.6734p PS=5.52u
+ PD=5.52u
M$5 VDD A Y VDD sg13_lv_pmos L=0.13u W=4.48u AS=1.0192p AD=1.0192p PS=7.42u
+ PD=7.42u
.ENDS sg13g2_inv_4

.SUBCKT sg13g2_nor3_1 VDD VSS C Y B A
M$1 VSS A Y VSS sg13_lv_nmos L=0.13u W=0.77u AS=0.2618p AD=0.1694p PS=2.22u
+ PD=1.21u
M$2 Y B VSS VSS sg13_lv_nmos L=0.13u W=0.77u AS=0.1694p AD=0.1463p PS=1.21u
+ PD=1.15u
M$3 VSS C Y VSS sg13_lv_nmos L=0.13u W=0.77u AS=0.1463p AD=0.2618p PS=1.15u
+ PD=2.22u
M$4 VDD A \$8 VDD sg13_lv_pmos L=0.13u W=1.12u AS=0.3808p AD=0.2464p PS=2.92u
+ PD=1.56u
M$5 \$8 B \$7 VDD sg13_lv_pmos L=0.13u W=1.12u AS=0.2464p AD=0.2128p PS=1.56u
+ PD=1.5u
M$6 \$7 C Y VDD sg13_lv_pmos L=0.13u W=1.12u AS=0.2128p AD=0.3808p PS=1.5u
+ PD=2.92u
.ENDS sg13g2_nor3_1

.SUBCKT sg13g2_nor4_1 VDD VSS B A C D Y
M$1 VSS A Y VSS sg13_lv_nmos L=0.13u W=0.74u AS=0.2516p AD=0.1406p PS=2.16u
+ PD=1.12u
M$2 Y B VSS VSS sg13_lv_nmos L=0.13u W=0.74u AS=0.1406p AD=0.1406p PS=1.12u
+ PD=1.12u
M$3 VSS C Y VSS sg13_lv_nmos L=0.13u W=0.74u AS=0.1406p AD=0.1406p PS=1.12u
+ PD=1.12u
M$4 Y D VSS VSS sg13_lv_nmos L=0.13u W=0.74u AS=0.1406p AD=0.237575p PS=1.12u
+ PD=2.16u
M$5 VDD A \$9 VDD sg13_lv_pmos L=0.13u W=1.12u AS=0.3808p AD=0.2128p PS=2.92u
+ PD=1.5u
M$6 \$9 B \$8 VDD sg13_lv_pmos L=0.13u W=1.12u AS=0.2128p AD=0.2128p PS=1.5u
+ PD=1.5u
M$7 \$8 C \$10 VDD sg13_lv_pmos L=0.13u W=1.12u AS=0.2128p AD=0.2128p PS=1.5u
+ PD=1.5u
M$8 \$10 D Y VDD sg13_lv_pmos L=0.13u W=1.12u AS=0.2128p AD=0.4368p PS=1.5u
+ PD=3.02u
.ENDS sg13g2_nor4_1

.SUBCKT sg13g2_mux2_1 VSS X S A1 A0 VDD
M$1 VSS S \$2 VSS sg13_lv_nmos L=0.13u W=0.55u AS=0.18945p AD=0.187p PS=1.27u
+ PD=1.78u
M$2 VSS S \$8 VSS sg13_lv_nmos L=0.13u W=0.74u AS=0.18945p AD=0.13135p PS=1.27u
+ PD=1.095u
M$3 \$8 A1 \$3 VSS sg13_lv_nmos L=0.13u W=0.74u AS=0.13135p AD=0.1628p
+ PS=1.095u PD=1.18u
M$4 \$3 A0 \$9 VSS sg13_lv_nmos L=0.13u W=0.74u AS=0.1628p AD=0.3367p PS=1.18u
+ PD=1.65u
M$5 \$9 \$2 VSS VSS sg13_lv_nmos L=0.13u W=0.74u AS=0.3367p AD=0.148p PS=1.65u
+ PD=1.14u
M$6 VSS \$3 X VSS sg13_lv_nmos L=0.13u W=0.74u AS=0.148p AD=0.4033p PS=1.14u
+ PD=2.57u
M$7 \$2 S VDD VDD sg13_lv_pmos L=0.13u W=0.84u AS=0.2856p AD=0.253p PS=2.36u
+ PD=1.53u
M$8 VDD S \$10 VDD sg13_lv_pmos L=0.13u W=1u AS=0.253p AD=0.3325p PS=1.53u
+ PD=1.665u
M$9 \$10 A0 \$3 VDD sg13_lv_pmos L=0.13u W=1u AS=0.3325p AD=0.2225p PS=1.665u
+ PD=1.445u
M$10 \$3 A1 \$11 VDD sg13_lv_pmos L=0.13u W=1u AS=0.2225p AD=0.2975p PS=1.445u
+ PD=1.595u
M$11 \$11 \$2 VDD VDD sg13_lv_pmos L=0.13u W=1u AS=0.2975p AD=0.2198p PS=1.595u
+ PD=1.52u
M$12 VDD \$3 X VDD sg13_lv_pmos L=0.13u W=1.12u AS=0.2198p AD=0.6048p PS=1.52u
+ PD=3.32u
.ENDS sg13g2_mux2_1

.SUBCKT sg13g2_buf_16 VSS X A VDD
M$1 VSS \$3 X VSS sg13_lv_nmos L=0.13u W=11.84u AS=2.3606p AD=2.2496p PS=18.96u
+ PD=17.92u
M$17 VSS A \$3 VSS sg13_lv_nmos L=0.13u W=4.44u AS=0.8436p AD=0.9546p PS=6.72u
+ PD=7.76u
M$23 VDD \$3 X VDD sg13_lv_pmos L=0.13u W=17.92u AS=3.5896p AD=3.4048p
+ PS=25.45u PD=24u
M$39 VDD A \$3 VDD sg13_lv_pmos L=0.13u W=6.72u AS=1.2768p AD=1.4448p PS=9u
+ PD=10.42u
.ENDS sg13g2_buf_16

.SUBCKT sg13g2_tiehi L_HI VDD VSS
M$1 VSS \$5 \$5 VSS sg13_lv_nmos L=0.13u W=0.3u AS=0.2043375p AD=0.111p
+ PS=1.585u PD=1.34u
M$2 VSS \$3 \$1 VSS sg13_lv_nmos L=0.13u W=0.795u AS=0.2043375p AD=0.274275p
+ PS=1.585u PD=2.28u
M$3 \$3 \$5 VDD VDD sg13_lv_pmos L=0.13u W=0.66u AS=0.2442p AD=0.4657125p
+ PS=2.06u PD=2.54u
M$4 VDD \$1 L_HI VDD sg13_lv_pmos L=0.13u W=1.155u AS=0.4657125p AD=0.3927p
+ PS=2.54u PD=2.99u
.ENDS sg13g2_tiehi

.SUBCKT sg13g2_dfrbpq_1 VSS RESET_B Q D CLK VDD
M$1 \$5 \$4 \$12 VSS sg13_lv_nmos L=0.13u W=0.42u AS=0.1296p AD=0.0798p
+ PS=1.52u PD=0.8u
M$2 \$12 \$18 \$6 VSS sg13_lv_nmos L=0.13u W=0.42u AS=0.0798p AD=0.2373p
+ PS=0.8u PD=1.97u
M$3 VSS \$4 \$18 VSS sg13_lv_nmos L=0.13u W=0.74u AS=0.317325p AD=0.2516p
+ PS=1.805u PD=2.16u
M$4 VSS CLK \$4 VSS sg13_lv_nmos L=0.13u W=0.74u AS=0.317325p AD=0.2516p
+ PS=1.805u PD=2.16u
M$5 \$14 \$4 \$7 VSS sg13_lv_nmos L=0.13u W=0.42u AS=0.12665p AD=0.1428p
+ PS=1.145u PD=1.52u
M$6 \$3 \$18 \$14 VSS sg13_lv_nmos L=0.13u W=0.74u AS=0.3473p AD=0.12665p
+ PS=2.71u PD=1.145u
M$7 \$5 D \$15 VSS sg13_lv_nmos L=0.13u W=0.42u AS=0.1428p AD=0.0609p PS=1.52u
+ PD=0.71u
M$8 \$15 RESET_B VSS VSS sg13_lv_nmos L=0.13u W=0.42u AS=0.0609p AD=0.1626p
+ PS=0.71u PD=1.415u
M$9 VSS \$12 \$3 VSS sg13_lv_nmos L=0.13u W=0.74u AS=0.1626p AD=0.2516p
+ PS=1.415u PD=2.16u
M$10 \$7 \$8 VSS VSS sg13_lv_nmos L=0.13u W=0.42u AS=0.1428p AD=0.0798p
+ PS=1.52u PD=0.8u
M$11 VSS RESET_B \$17 VSS sg13_lv_nmos L=0.13u W=0.42u AS=0.0798p AD=0.0378p
+ PS=0.8u PD=0.6u
M$12 \$17 \$14 \$8 VSS sg13_lv_nmos L=0.13u W=0.42u AS=0.0378p AD=0.1428p
+ PS=0.6u PD=1.52u
M$13 \$9 \$14 VSS VSS sg13_lv_nmos L=0.13u W=0.74u AS=0.2516p AD=0.1406p
+ PS=2.16u PD=1.12u
M$14 VSS \$9 Q VSS sg13_lv_nmos L=0.13u W=0.74u AS=0.1406p AD=0.2516p PS=1.12u
+ PD=2.16u
M$15 VSS RESET_B \$16 VSS sg13_lv_nmos L=0.13u W=0.42u AS=0.1701p AD=0.0378p
+ PS=1.65u PD=0.6u
M$16 \$16 \$3 \$6 VSS sg13_lv_nmos L=0.13u W=0.42u AS=0.0378p AD=0.1428p
+ PS=0.6u PD=1.52u
M$17 \$14 \$18 \$21 VDD sg13_lv_pmos L=0.13u W=0.42u AS=0.2048p AD=0.09345p
+ PS=1.63u PD=0.865u
M$18 \$21 \$8 VDD VDD sg13_lv_pmos L=0.13u W=0.42u AS=0.09345p AD=0.204p
+ PS=0.865u PD=1.835u
M$19 VDD RESET_B \$8 VDD sg13_lv_pmos L=0.13u W=0.42u AS=0.204p AD=0.0798p
+ PS=1.835u PD=0.8u
M$20 \$8 \$14 VDD VDD sg13_lv_pmos L=0.13u W=0.42u AS=0.0798p AD=0.4659p
+ PS=0.8u PD=3.65u
M$21 \$3 \$4 \$14 VDD sg13_lv_pmos L=0.13u W=1u AS=0.34p AD=0.2048p PS=2.68u
+ PD=1.63u
M$22 \$9 \$14 VDD VDD sg13_lv_pmos L=0.13u W=1.12u AS=0.3864p AD=0.2128p
+ PS=2.93u PD=1.5u
M$23 VDD \$9 Q VDD sg13_lv_pmos L=0.13u W=1.12u AS=0.2128p AD=0.3808p PS=1.5u
+ PD=2.92u
M$24 VDD D \$5 VDD sg13_lv_pmos L=0.13u W=0.42u AS=0.1428p AD=0.0798p PS=1.52u
+ PD=0.8u
M$25 VDD RESET_B \$5 VDD sg13_lv_pmos L=0.13u W=0.42u AS=0.3623875p AD=0.0798p
+ PS=2.605u PD=0.8u
M$26 VDD \$12 \$3 VDD sg13_lv_pmos L=0.13u W=1u AS=0.3623875p AD=0.34p
+ PS=2.605u PD=2.68u
M$27 \$18 \$4 VDD VDD sg13_lv_pmos L=0.13u W=1.12u AS=0.3864p AD=0.41165p
+ PS=2.93u PD=2.12u
M$28 VDD CLK \$4 VDD sg13_lv_pmos L=0.13u W=1.12u AS=0.41165p AD=0.4088p
+ PS=2.12u PD=2.97u
M$29 \$12 RESET_B VDD VDD sg13_lv_pmos L=0.13u W=0.42u AS=0.147p AD=0.1563p
+ PS=1.54u PD=1.22u
M$30 VDD \$3 \$20 VDD sg13_lv_pmos L=0.13u W=0.42u AS=0.1563p AD=0.063p
+ PS=1.22u PD=0.72u
M$31 \$20 \$4 \$12 VDD sg13_lv_pmos L=0.13u W=0.42u AS=0.063p AD=0.0798p
+ PS=0.72u PD=0.8u
M$32 \$12 \$18 \$5 VDD sg13_lv_pmos L=0.13u W=0.42u AS=0.0798p AD=0.1428p
+ PS=0.8u PD=1.52u
.ENDS sg13g2_dfrbpq_1

.SUBCKT sg13g2_a21oi_1 Y VSS A2 VDD A1 B1
M$1 VSS B1 Y VSS sg13_lv_nmos L=0.13u W=0.74u AS=0.2516p AD=0.1406p PS=2.16u
+ PD=1.12u
M$2 Y A1 \$8 VSS sg13_lv_nmos L=0.13u W=0.74u AS=0.1406p AD=0.1406p PS=1.12u
+ PD=1.12u
M$3 \$8 A2 VSS VSS sg13_lv_nmos L=0.13u W=0.74u AS=0.1406p AD=0.2516p PS=1.12u
+ PD=2.16u
M$4 Y B1 \$3 VDD sg13_lv_pmos L=0.13u W=1.12u AS=0.3808p AD=0.2128p PS=2.92u
+ PD=1.5u
M$5 \$3 A1 VDD VDD sg13_lv_pmos L=0.13u W=1.12u AS=0.2128p AD=0.2128p PS=1.5u
+ PD=1.5u
M$6 VDD A2 \$3 VDD sg13_lv_pmos L=0.13u W=1.12u AS=0.2128p AD=0.3808p PS=1.5u
+ PD=2.92u
.ENDS sg13g2_a21oi_1

.SUBCKT sg13g2_nand3_1 VSS VDD Y B C A
M$1 VSS C \$8 VSS sg13_lv_nmos L=0.13u W=0.74u AS=0.2886p AD=0.1406p PS=2.26u
+ PD=1.12u
M$2 \$8 B \$7 VSS sg13_lv_nmos L=0.13u W=0.74u AS=0.1406p AD=0.1406p PS=1.12u
+ PD=1.12u
M$3 \$7 A Y VSS sg13_lv_nmos L=0.13u W=0.74u AS=0.1406p AD=0.2516p PS=1.12u
+ PD=2.16u
M$4 VDD C Y VDD sg13_lv_pmos L=0.13u W=1.12u AS=0.3808p AD=0.2128p PS=2.92u
+ PD=1.5u
M$5 Y B VDD VDD sg13_lv_pmos L=0.13u W=1.12u AS=0.2128p AD=0.2128p PS=1.5u
+ PD=1.5u
M$6 VDD A Y VDD sg13_lv_pmos L=0.13u W=1.12u AS=0.2128p AD=0.3808p PS=1.5u
+ PD=2.92u
.ENDS sg13g2_nand3_1

.SUBCKT sg13g2_and2_1 VDD VSS X A B
M$1 \$4 A \$7 VSS sg13_lv_nmos L=0.13u W=0.64u AS=0.2176p AD=0.1216p PS=1.96u
+ PD=1.02u
M$2 VSS B \$7 VSS sg13_lv_nmos L=0.13u W=0.64u AS=0.1331p AD=0.1216p PS=1.12u
+ PD=1.02u
M$3 VSS \$4 X VSS sg13_lv_nmos L=0.13u W=0.74u AS=0.1331p AD=0.2516p PS=1.12u
+ PD=2.16u
M$4 VDD A \$4 VDD sg13_lv_pmos L=0.13u W=0.84u AS=0.2856p AD=0.1596p PS=2.36u
+ PD=1.22u
M$5 VDD B \$4 VDD sg13_lv_pmos L=0.13u W=0.84u AS=0.1918p AD=0.1596p PS=1.5u
+ PD=1.22u
M$6 VDD \$4 X VDD sg13_lv_pmos L=0.13u W=1.12u AS=0.1918p AD=0.3808p PS=1.5u
+ PD=2.92u
.ENDS sg13g2_and2_1

.SUBCKT sg13g2_xnor2_1 VDD VSS Y B A
M$1 VSS A \$8 VSS sg13_lv_nmos L=0.13u W=0.64u AS=0.2272p AD=0.0784p PS=1.99u
+ PD=0.885u
M$2 \$8 B \$7 VSS sg13_lv_nmos L=0.13u W=0.64u AS=0.0784p AD=0.2176p PS=0.885u
+ PD=1.96u
M$3 VSS A \$3 VSS sg13_lv_nmos L=0.13u W=0.74u AS=0.1898p AD=0.2516p PS=1.36u
+ PD=2.16u
M$4 VSS B \$3 VSS sg13_lv_nmos L=0.13u W=0.74u AS=0.1898p AD=0.1406p PS=1.36u
+ PD=1.12u
M$5 \$3 \$7 Y VSS sg13_lv_nmos L=0.13u W=0.74u AS=0.1406p AD=0.2516p PS=1.12u
+ PD=2.16u
M$6 VDD A \$7 VDD sg13_lv_pmos L=0.13u W=0.84u AS=0.4536p AD=0.1596p PS=2.76u
+ PD=1.22u
M$7 VDD B \$7 VDD sg13_lv_pmos L=0.13u W=0.84u AS=0.2891p AD=0.1596p PS=1.695u
+ PD=1.22u
M$8 VDD A \$9 VDD sg13_lv_pmos L=0.13u W=1.12u AS=0.2891p AD=0.1428p PS=1.695u
+ PD=1.375u
M$9 \$9 B Y VDD sg13_lv_pmos L=0.13u W=1.12u AS=0.1428p AD=0.2408p PS=1.375u
+ PD=1.55u
M$10 Y \$7 VDD VDD sg13_lv_pmos L=0.13u W=1.12u AS=0.2408p AD=0.3808p PS=1.55u
+ PD=2.92u
.ENDS sg13g2_xnor2_1

.SUBCKT sg13g2_nand4_1 VDD A VSS Y B C D
M$1 VSS D \$10 VSS sg13_lv_nmos L=0.13u W=0.74u AS=0.2516p AD=0.1406p PS=2.16u
+ PD=1.12u
M$2 \$10 C \$9 VSS sg13_lv_nmos L=0.13u W=0.74u AS=0.1406p AD=0.1406p PS=1.12u
+ PD=1.12u
M$3 \$9 B \$8 VSS sg13_lv_nmos L=0.13u W=0.74u AS=0.1406p AD=0.1406p PS=1.12u
+ PD=1.12u
M$4 \$8 A Y VSS sg13_lv_nmos L=0.13u W=0.74u AS=0.1406p AD=0.2516p PS=1.12u
+ PD=2.16u
M$5 VDD D Y VDD sg13_lv_pmos L=0.13u W=1.12u AS=0.3808p AD=0.2128p PS=2.92u
+ PD=1.5u
M$6 Y C VDD VDD sg13_lv_pmos L=0.13u W=1.12u AS=0.2128p AD=0.2128p PS=1.5u
+ PD=1.5u
M$7 VDD B Y VDD sg13_lv_pmos L=0.13u W=1.12u AS=0.2128p AD=0.2128p PS=1.5u
+ PD=1.5u
M$8 Y A VDD VDD sg13_lv_pmos L=0.13u W=1.12u AS=0.2128p AD=0.3808p PS=1.5u
+ PD=2.92u
.ENDS sg13g2_nand4_1

.SUBCKT sg13g2_xor2_1 VSS X VDD B A
M$1 VSS A \$1 VSS sg13_lv_nmos L=0.13u W=0.55u AS=0.374p AD=0.174625p PS=2.46u
+ PD=1.185u
M$2 VSS B \$1 VSS sg13_lv_nmos L=0.13u W=0.55u AS=0.15245p AD=0.174625p
+ PS=1.17u PD=1.185u
M$3 VSS A \$8 VSS sg13_lv_nmos L=0.13u W=0.74u AS=0.15245p AD=0.0888p PS=1.17u
+ PD=0.98u
M$4 \$8 B X VSS sg13_lv_nmos L=0.13u W=0.74u AS=0.0888p AD=0.1628p PS=0.98u
+ PD=1.18u
M$5 X \$1 VSS VSS sg13_lv_nmos L=0.13u W=0.74u AS=0.1628p AD=0.3108p PS=1.18u
+ PD=2.32u
M$6 \$3 A VDD VDD sg13_lv_pmos L=0.13u W=1.12u AS=0.3808p AD=0.2128p PS=2.92u
+ PD=1.5u
M$7 VDD B \$3 VDD sg13_lv_pmos L=0.13u W=1.12u AS=0.2128p AD=0.2128p PS=1.5u
+ PD=1.5u
M$8 \$3 \$1 X VDD sg13_lv_pmos L=0.13u W=1.12u AS=0.2128p AD=0.3808p PS=1.5u
+ PD=2.92u
M$9 VDD A \$9 VDD sg13_lv_pmos L=0.13u W=1u AS=0.36p AD=0.1225p PS=2.72u
+ PD=1.245u
M$10 \$9 B \$1 VDD sg13_lv_pmos L=0.13u W=1u AS=0.1225p AD=0.34p PS=1.245u
+ PD=2.68u
.ENDS sg13g2_xor2_1

.SUBCKT sg13g2_o21ai_1 VSS Y VDD B1 A2 A1
M$1 \$2 A1 VSS VSS sg13_lv_nmos L=0.15u W=0.74u AS=0.2516p AD=0.1406p PS=2.16u
+ PD=1.12u
M$2 VSS A2 \$2 VSS sg13_lv_nmos L=0.15u W=0.74u AS=0.1406p AD=0.1406p PS=1.12u
+ PD=1.12u
M$3 \$2 B1 Y VSS sg13_lv_nmos L=0.15u W=0.74u AS=0.1406p AD=0.2516p PS=1.12u
+ PD=2.16u
M$4 VDD A1 \$8 VDD sg13_lv_pmos L=0.15u W=1.12u AS=0.3808p AD=0.2128p PS=2.92u
+ PD=1.5u
M$5 \$8 A2 Y VDD sg13_lv_pmos L=0.15u W=1.12u AS=0.2128p AD=0.2128p PS=1.5u
+ PD=1.5u
M$6 Y B1 VDD VDD sg13_lv_pmos L=0.15u W=1.12u AS=0.2128p AD=0.3808p PS=1.5u
+ PD=2.92u
.ENDS sg13g2_o21ai_1

.SUBCKT sg13g2_nand2b_1 VDD VSS B A_N Y
M$1 VSS A_N \$6 VSS sg13_lv_nmos L=0.13u W=0.55u AS=0.14505p AD=0.187p PS=1.15u
+ PD=1.78u
M$2 VSS B \$7 VSS sg13_lv_nmos L=0.13u W=0.74u AS=0.14505p AD=0.1406p PS=1.15u
+ PD=1.12u
M$3 \$7 \$6 Y VSS sg13_lv_nmos L=0.13u W=0.74u AS=0.1406p AD=0.333p PS=1.12u
+ PD=2.38u
M$4 \$6 A_N VDD VDD sg13_lv_pmos L=0.13u W=0.84u AS=0.2856p AD=0.2198p PS=2.36u
+ PD=1.53u
M$5 VDD B Y VDD sg13_lv_pmos L=0.13u W=1.12u AS=0.2198p AD=0.2128p PS=1.53u
+ PD=1.5u
M$6 Y \$6 VDD VDD sg13_lv_pmos L=0.13u W=1.12u AS=0.2128p AD=0.3808p PS=1.5u
+ PD=2.92u
.ENDS sg13g2_nand2b_1

.SUBCKT sg13g2_nand2_1 VDD VSS Y A B
M$1 VSS B \$6 VSS sg13_lv_nmos L=0.13u W=0.74u AS=0.2516p AD=0.1406p PS=2.16u
+ PD=1.12u
M$2 \$6 A Y VSS sg13_lv_nmos L=0.13u W=0.74u AS=0.1406p AD=0.2516p PS=1.12u
+ PD=2.16u
M$3 VDD B Y VDD sg13_lv_pmos L=0.13u W=1.12u AS=0.3808p AD=0.2128p PS=2.92u
+ PD=1.5u
M$4 Y A VDD VDD sg13_lv_pmos L=0.13u W=1.12u AS=0.2128p AD=0.3808p PS=1.5u
+ PD=2.92u
.ENDS sg13g2_nand2_1

.SUBCKT sg13g2_nor2_1 VDD VSS B A Y
M$1 VSS A Y VSS sg13_lv_nmos L=0.13u W=0.74u AS=0.2516p AD=0.1406p PS=2.16u
+ PD=1.12u
M$2 Y B VSS VSS sg13_lv_nmos L=0.13u W=0.74u AS=0.1406p AD=0.2516p PS=1.12u
+ PD=2.16u
M$3 VDD A \$6 VDD sg13_lv_pmos L=0.13u W=1.12u AS=0.4032p AD=0.1176p PS=2.96u
+ PD=1.33u
M$4 \$6 B Y VDD sg13_lv_pmos L=0.13u W=1.12u AS=0.1176p AD=0.3808p PS=1.33u
+ PD=2.92u
.ENDS sg13g2_nor2_1

.SUBCKT sg13g2_decap_4 VDD VSS
M$1 VSS VDD VSS VSS sg13_lv_nmos L=1u W=0.42u AS=0.1428p AD=0.1428p PS=1.52u
+ PD=1.52u
M$2 VDD VSS VDD VDD sg13_lv_pmos L=1u W=1u AS=0.34p AD=0.34p PS=2.68u PD=2.68u
.ENDS sg13g2_decap_4

.SUBCKT sg13g2_decap_8 VDD VSS
M$1 VSS VDD VSS VSS sg13_lv_nmos L=1u W=0.84u AS=0.2226p AD=0.2226p PS=2.32u
+ PD=2.32u
M$3 VDD VSS VDD VDD sg13_lv_pmos L=1u W=2u AS=0.53p AD=0.53p PS=4.06u PD=4.06u
.ENDS sg13g2_decap_8
