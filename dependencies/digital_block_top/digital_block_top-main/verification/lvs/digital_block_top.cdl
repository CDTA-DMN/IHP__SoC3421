* CDL Netlist generated by OpenROAD

*.BUSDELIMITER [
.include "/foss/pdks/ihp-sg13g2/libs.ref/sg13g2_stdcell/cdl/sg13g2_stdcell.cdl"
.SUBCKT digital_block_top ADC_INPUT ADC_INPUT_VALID CLK CS
+ DATA_READY FREEZE MISO MOSI RESET SCAN_OUT SCAN_VALID SCK
+ VDD VSS
Xplace559 net558 net559 VDD VSS sg13g2_buf_1
Xclkbuf_3_1__f_CLK clknet_3_1__leaf_CLK clknet_0_CLK VDD VSS
+ sg13g2_buf_16
Xplace557 net556 net242 VDD VSS sg13g2_buf_1
Xclkbuf_leaf_1_CLK clknet_leaf_1_CLK clknet_3_0__leaf_CLK
+ VDD VSS sg13g2_buf_16
Xclkbuf_leaf_0_CLK clknet_leaf_0_CLK clknet_3_0__leaf_CLK
+ VDD VSS sg13g2_buf_16
Xplace556 net555 net242 VDD VSS sg13g2_buf_1
X_1073_ _0627_ net525 net522 VDD VSS sg13g2_nor2_1
Xclkbuf_leaf_2_CLK clknet_leaf_2_CLK clknet_3_0__leaf_CLK
+ VDD VSS sg13g2_buf_16
X_1075_ _0629_ net238 serializer_inst.fake_adc.skid.bypass_rg
+ VDD VSS sg13g2_nand2b_2
X_1076_ _0630_ net519 _0627_ _0629_ VDD VSS sg13g2_mux2_1
X_1077_ _0631_ afe_controller_inst.AFE_CRTL_OUTPUTS\[1\] net522
+ VDD VSS sg13g2_nor2b_1
X_1078_ _0632_ net519 _0629_ _0631_ VDD VSS sg13g2_a21o_1
X_1079_ _0633_ net525 VDD VSS sg13g2_inv_1
Xplace555 net554 net555 VDD VSS sg13g2_buf_1
Xplace549 net548 net549 VDD VSS sg13g2_buf_1
X_1082_ _0636_ net523 _0630_ _0632_ _0633_ net518 VDD VSS
+ sg13g2_a221oi_1
X_1083_ _0637_ afe_controller_inst.AFE_CRTL_OUTPUTS\[3\] VDD
+ VSS sg13g2_inv_1
Xplace544 net543 net544 VDD VSS sg13g2_buf_1
X_1085_ _0639_ net519 net526 VDD VSS sg13g2_nor2b_1
X_1086_ _0640_ afe_controller_inst.AFE_CRTL_OUTPUTS\[4\] VDD
+ VSS sg13g2_inv_1
X_1087_ _0641_ _0637_ _0627_ _0631_ _0639_ _0640_ VDD VSS
+ sg13g2_a221oi_1
Xplace543 net542 net543 VDD VSS sg13g2_buf_1
X_1089_ _0643_ net240 afe_controller_inst.CONFIG_VALID VDD
+ VSS sg13g2_nand2_1
X_1090_ _0644_ net562 _0643_ VDD VSS sg13g2_nor2_2
X_1091_ _0645_ _0641_ _0644_ VDD VSS sg13g2_nand2b_1
X_1092_ _0646_ net565 net561 VDD VSS sg13g2_nor2_1
X_1093_ _0647_ net526 _0646_ VDD VSS sg13g2_nand2_1
X_1094_ _0648_ _0636_ _0645_ _0647_ VDD VSS sg13g2_o21ai_1
Xplace542 net541 net544 VDD VSS sg13g2_buf_1
X_1096_ _0650_ afe_controller_inst.AFE_CRTL_OUTPUTS\[0\] afe_controller_inst.AFE_CRTL_OUTPUTS\[2\]
+ afe_controller_inst.AFE_CRTL_OUTPUTS\[3\] VDD VSS sg13g2_or3_1
X_1097_ _0651_ net524 afe_controller_inst.CONFIG_VALUES\[0\]
+ VDD VSS sg13g2_nand2b_1
X_1098_ _0652_ net517 afe_controller_inst.valid_control.state
+ _0650_ _0651_ VDD VSS sg13g2_nor4_1
X_1099_ _0653_ afe_controller_inst.fifo.w_ptr\[2\] afe_controller_inst.fifo.r_ptr\[2\]
+ VDD VSS sg13g2_xor2_1
X_1100_ _0654_ net517 _0653_ _0650_ _0651_ VDD VSS sg13g2_nor4_1
Xplace548 net547 net552 VDD VSS sg13g2_buf_1
X_1102_ _0656_ afe_controller_inst.fifo.r_ptr\[1\] afe_controller_inst.fifo.w_ptr\[1\]
+ VDD VSS sg13g2_xor2_1
X_1103_ _0657_ afe_controller_inst.fifo.r_ptr\[0\] afe_controller_inst.fifo.w_ptr\[0\]
+ VDD VSS sg13g2_xor2_1
X_1104_ _0658_ net563 _0656_ _0657_ VDD VSS sg13g2_nor3_2
X_1105_ _0659_ _0652_ _0654_ _0658_ VDD VSS sg13g2_mux2_1
X_1106_ _0660_ afe_controller_inst.CONFIG_VALUES\[3\] _0659_
+ _0644_ VDD VSS sg13g2_nand3b_1
X_1107_ _0661_ _0648_ _0660_ VDD VSS sg13g2_nand2b_1
Xplace545 net544 net545 VDD VSS sg13g2_buf_1
X_1109_ _0662_ net524 VDD VSS sg13g2_inv_1
X_1110_ _0663_ afe_controller_inst.AFE_CRTL_OUTPUTS\[0\] net522
+ afe_controller_inst.AFE_CRTL_OUTPUTS\[3\] VDD VSS sg13g2_nor3_2
X_1111_ _0664_ _0640_ afe_controller_inst.CONFIG_VALUES\[0\]
+ _0662_ _0663_ VDD VSS sg13g2_nand4_1
X_1112_ _0665_ afe_controller_inst.CONFIG_VALUES\[2\] afe_controller_inst.CONFIG_VALUES\[3\]
+ VDD VSS sg13g2_xnor2_1
X_1113_ _0666_ afe_controller_inst.valid_control.state _0658_
+ _0664_ _0665_ VDD VSS sg13g2_nor4_2
X_1114_ _0667_ net563 _0656_ _0657_ VDD VSS sg13g2_or3_1
X_1115_ _0668_ _0667_ _0653_ _0664_ _0665_ VDD VSS sg13g2_nor4_2
X_1116_ _0669_ _0666_ _0668_ _0644_ VDD VSS sg13g2_o21ai_1
X_1117_ _0670_ net518 afe_controller_inst.AFE_CRTL_OUTPUTS\[3\]
+ VDD VSS sg13g2_nor2b_1
X_1118_ _0671_ net238 serializer_inst.fake_adc.skid.bypass_rg
+ VDD VSS sg13g2_nor2b_1
X_1119_ _0672_ net520 _0671_ afe_controller_inst.AFE_CRTL_OUTPUTS\[0\]
+ VDD VSS sg13g2_mux2_1
X_1120_ _0673_ _0670_ _0672_ _0663_ VDD VSS sg13g2_a21o_1
X_1121_ _0674_ _0662_ net561 _0643_ VDD VSS sg13g2_nor3_1
Xplace547 net546 net552 VDD VSS sg13g2_buf_1
X_1123_ _0676_ net517 net520 net519 VDD VSS sg13g2_o21ai_1
X_1124_ _0677_ net526 _0662_ _0644_ _0676_ VDD VSS sg13g2_and4_1
X_1125_ _0678_ net523 _0646_ _0673_ _0674_ _0677_ VDD VSS
+ sg13g2_a221oi_1
X_1126_ _0679_ _0669_ _0678_ VDD VSS sg13g2_and2_1
Xplace546 net545 net546 VDD VSS sg13g2_buf_1
X_1128_ _0158_ _0679_ VDD VSS sg13g2_inv_1
Xplace554 net553 net554 VDD VSS sg13g2_buf_1
X_1130_ _0682_ _0633_ afe_controller_inst.AFE_CRTL_OUTPUTS\[1\]
+ _0670_ VDD VSS sg13g2_nand3_1
X_1131_ _0683_ net525 afe_controller_inst.AFE_CRTL_OUTPUTS\[1\]
+ VDD VSS sg13g2_nand2_1
X_1132_ _0684_ net518 _0637_ _0683_ VDD VSS sg13g2_nand3_1
X_1133_ _0685_ _0682_ _0684_ net521 VDD VSS sg13g2_a21oi_1
Xplace553 net552 net242 VDD VSS sg13g2_buf_1
Xplace552 net551 net552 VDD VSS sg13g2_buf_1
X_1136_ _0688_ net526 net520 VDD VSS sg13g2_and2_1
X_1137_ _0689_ net523 _0629_ _0688_ _0670_ VDD VSS sg13g2_nand4_1
X_1138_ _0690_ net567 afe_controller_inst.CONFIG_VALID _0689_
+ VDD VSS sg13g2_nand3_1
X_1139_ _0691_ _0685_ _0690_ VDD VSS sg13g2_nor2_1
X_1140_ _0692_ net517 net566 VDD VSS sg13g2_nor2_1
X_1141_ _0693_ net561 _0691_ _0692_ VDD VSS sg13g2_or3_1
Xplace551 net550 net551 VDD VSS sg13g2_buf_1
X_1143_ _0224_ _0693_ VDD VSS sg13g2_inv_1
X_1144_ _0695_ net479 _0158_ _0224_ VDD VSS sg13g2_a21oi_1
X_1145_ _0696_ _0633_ _0637_ net521 VDD VSS sg13g2_o21ai_1
X_1146_ _0697_ afe_controller_inst.AFE_CRTL_OUTPUTS\[1\] net522
+ VDD VSS sg13g2_and2_1
X_1147_ _0698_ net522 afe_controller_inst.AFE_CRTL_OUTPUTS\[3\]
+ VDD VSS sg13g2_nor2b_1
X_1148_ _0699_ _0697_ _0698_ _0671_ VDD VSS sg13g2_mux2_1
X_1149_ _0700_ net521 net525 VDD VSS sg13g2_nand2b_1
X_1150_ _0701_ afe_controller_inst.AFE_CRTL_OUTPUTS\[3\] afe_controller_inst.AFE_CRTL_OUTPUTS\[1\]
+ VDD VSS sg13g2_nor2b_1
X_1151_ _0702_ _0700_ _0701_ net518 VDD VSS sg13g2_a21o_1
X_1152_ _0703_ _0662_ _0696_ _0699_ net525 _0702_ VDD VSS
+ sg13g2_a221oi_1
X_1153_ _0704_ _0643_ _0703_ _0666_ _0668_ VDD VSS sg13g2_nor4_1
X_1154_ _0705_ net566 VDD VSS sg13g2_inv_1
X_1155_ _0706_ net520 VDD VSS sg13g2_inv_1
X_1156_ _0707_ _0705_ _0706_ net563 VDD VSS sg13g2_a21oi_1
X_1157_ _0708_ _0704_ _0707_ VDD VSS sg13g2_nand2b_1
Xplace550 net549 net551 VDD VSS sg13g2_buf_1
X_1159_ _0710_ _0708_ VDD VSS sg13g2_inv_4
Xclkbuf_leaf_3_CLK clknet_leaf_3_CLK clknet_3_1__leaf_CLK
+ VDD VSS sg13g2_buf_16
X_1161_ _0711_ afe_controller_inst.CONFIG_VALUES\[2\] afe_controller_inst.CONFIG_VALUES\[3\]
+ VDD VSS sg13g2_nand2b_1
X_1162_ _0712_ net517 afe_controller_inst.valid_control.state
+ _0650_ _0651_ VDD VSS sg13g2_or4_1
X_1163_ _0713_ net517 _0653_ _0650_ _0651_ VDD VSS sg13g2_or4_1
X_1164_ _0714_ _0712_ _0713_ _0658_ VDD VSS sg13g2_mux2_2
X_1165_ _0715_ net521 afe_controller_inst.AFE_CRTL_OUTPUTS\[1\]
+ VDD VSS sg13g2_nor2b_1
X_1166_ _0716_ net525 _0715_ _0700_ VDD VSS sg13g2_o21ai_1
X_1167_ _0717_ net519 _0629_ VDD VSS sg13g2_nand2_1
X_1168_ _0718_ net525 net522 VDD VSS sg13g2_nand2_1
X_1169_ _0719_ net518 _0662_ _0718_ VDD VSS sg13g2_nor3_1
X_1170_ _0720_ _0640_ net523 net519 _0718_ VDD VSS sg13g2_nor4_1
X_1171_ _0721_ _0670_ _0716_ _0717_ _0719_ _0720_ VDD VSS
+ sg13g2_a221oi_1
X_1172_ _0722_ _0711_ _0714_ _0721_ VDD VSS sg13g2_o21ai_1
X_1173_ _0191_ _0646_ VDD VSS sg13g2_inv_1
X_1174_ _0723_ _0637_ _0191_ VDD VSS sg13g2_nor2_1
X_1175_ _0724_ _0644_ _0722_ _0723_ VDD VSS sg13g2_a21oi_2
X_1176_ _0144_ _0724_ VDD VSS sg13g2_inv_8
X_1177_ _0725_ _0710_ net471 VDD VSS sg13g2_nor2_1
X_1178_ _0726_ _0695_ _0725_ VDD VSS sg13g2_nand2b_1
X_1179_ _0727_ net472 _0661_ net478 VDD VSS sg13g2_nor3_1
X_1180_ _0728_ _0661_ net478 VDD VSS sg13g2_and2_1
Xplace535 net534 net535 VDD VSS sg13g2_buf_1
X_1182_ _0730_ _0724_ _0224_ VDD VSS sg13g2_nor2_2
X_1183_ _0731_ _0727_ _0728_ _0730_ VDD VSS sg13g2_o21ai_1
X_1184_ _0732_ net471 _0661_ _0158_ VDD VSS sg13g2_o21ai_1
X_1185_ _0733_ net472 net477 _0732_ VDD VSS sg13g2_nand3_1
X_1186_ _0006_ _0726_ _0731_ _0733_ VDD VSS sg13g2_nand3_1
X_1187_ _0734_ _0724_ net478 VDD VSS sg13g2_nor2_2
X_1188_ _0735_ _0734_ _0728_ net472 VDD VSS sg13g2_mux2_1
X_1189_ _0736_ net472 net478 VDD VSS sg13g2_nor2_1
X_1190_ _0737_ net479 _0679_ VDD VSS sg13g2_nand2_1
X_1191_ _0738_ _0736_ _0737_ VDD VSS sg13g2_nand2b_1
X_1192_ _0739_ net471 net477 VDD VSS sg13g2_nor2_1
X_1193_ _0740_ _0708_ net471 _0224_ net479 VDD VSS sg13g2_nor4_1
X_1194_ _0005_ net477 _0735_ _0738_ _0739_ _0740_ VDD VSS
+ sg13g2_a221oi_1
X_1195_ _0741_ _0724_ _0661_ VDD VSS sg13g2_xnor2_1
X_1196_ _0742_ net472 net477 net478 VDD VSS sg13g2_nand3_1
X_1197_ _0743_ _0736_ _0730_ _0739_ _0728_ VDD VSS sg13g2_a22oi_1
X_1198_ _0004_ _0741_ _0742_ _0743_ VDD VSS sg13g2_o21ai_1
X_1199_ _0744_ net479 _0679_ VDD VSS sg13g2_nand2b_2
X_1200_ _0745_ _0710_ net471 _0224_ _0744_ VDD VSS sg13g2_or4_1
X_1201_ _0003_ _0725_ net477 _0745_ VDD VSS sg13g2_o21ai_1
X_1202_ _0746_ net471 _0744_ net477 VDD VSS sg13g2_o21ai_1
X_1203_ _0747_ _0710_ _0158_ _0224_ VDD VSS sg13g2_a21oi_1
X_1204_ _0748_ _0724_ _0747_ VDD VSS sg13g2_nor2_1
X_1205_ _0002_ _0224_ _0737_ _0746_ _0708_ _0748_ VDD VSS
+ sg13g2_a221oi_1
X_1206_ _0749_ _0708_ _0728_ _0724_ VDD VSS sg13g2_o21ai_1
X_1207_ _0750_ _0710_ _0744_ _0730_ VDD VSS sg13g2_o21ai_1
X_1208_ _0001_ net477 _0749_ _0750_ VDD VSS sg13g2_o21ai_1
X_1209_ _0751_ _0744_ _0708_ VDD VSS sg13g2_nand2b_1
X_1210_ _0752_ net472 _0737_ VDD VSS sg13g2_nand2_1
X_1211_ _0000_ _0751_ _0730_ _0739_ _0752_ VDD VSS sg13g2_a22oi_1
Xplace565 net564 net567 VDD VSS sg13g2_buf_1
Xplace534 net533 _0705_ VDD VSS sg13g2_buf_1
X_1214_ _0755_ main_fsm_top_inst.MAIN_TOP_OUTPUTS\[0\] VDD
+ VSS sg13g2_inv_1
X_1215_ _0756_ main_fsm_top_inst.MAIN_TOP_OUTPUTS\[1\] _0755_
+ VDD VSS sg13g2_nand2_1
Xplace536 net535 net546 VDD VSS sg13g2_buf_1
X_1217_ net245 main_fsm_top_inst.spi_top_inst.load_in\[7\]
+ main_fsm_top_inst.spi_top_inst.spi_reg.bit_cell7.DATA_OUT
+ _0756_ VDD VSS sg13g2_mux2_1
Xplace533 net532 _0931_ VDD VSS sg13g2_buf_1
Xplace532 net531 _0009_ VDD VSS sg13g2_buf_1
Xplace566 net565 net566 VDD VSS sg13g2_buf_1
X_1221_ _0761_ afe_controller_inst.valid_control.state VDD
+ VSS sg13g2_inv_1
X_1222_ _0762_ net563 _0656_ _0657_ _0653_ VDD VSS sg13g2_nor4_1
X_1223_ _0763_ _0761_ _0667_ _0762_ VDD VSS sg13g2_a21o_1
Xplace531 net530 _0009_ VDD VSS sg13g2_buf_1
X_1225_ _0765_ afe_controller_inst.clear net566 VDD VSS sg13g2_nand2b_1
Xplace529 net528 _0010_ VDD VSS sg13g2_buf_1
X_1227_ _0767_ _0763_ _0765_ VDD VSS sg13g2_nor2_1
X_1228_ _0768_ net533 afe_controller_inst.valid_control.state
+ _0767_ VDD VSS sg13g2_a21oi_1
X_1229_ _0012_ net563 _0768_ VDD VSS sg13g2_nor2_1
Xplace567 net566 net567 VDD VSS sg13g2_buf_1
Xplace530 net529 _0010_ VDD VSS sg13g2_buf_1
Xplace528 net527 afe_controller_inst.fifo.w_ptr\[1\] VDD VSS
+ sg13g2_buf_1
Xplace568 net567 net240 VDD VSS sg13g2_buf_1
Xplace527 net526 afe_controller_inst.AFE_CRTL_OUTPUTS\[0\]
+ VDD VSS sg13g2_buf_1
Xplace526 net525 net526 VDD VSS sg13g2_buf_1
X_1236_ _0775_ main_fsm_top_inst.MAIN_TOP_OUTPUTS\[8\] main_fsm_top_inst.MAIN_TOP_OUTPUTS\[9\]
+ VDD VSS sg13g2_nand2b_1
X_1237_ _0776_ net514 afe_controller_inst.CONFIG_VALID _0775_
+ VDD VSS sg13g2_nor3_1
Xclkbuf_leaf_21_CLK clknet_leaf_21_CLK clknet_3_4__leaf_CLK
+ VDD VSS sg13g2_buf_16
X_1239_ _0778_ main_fsm_top_inst.spi_top_inst.counter_module.COUNTER\[0\]
+ main_fsm_top_inst.spi_top_inst.counter_module.COUNTER\[1\]
+ main_fsm_top_inst.spi_top_inst.counter_module.COUNTER\[2\]
+ main_fsm_top_inst.spi_top_inst.counter_module.COUNTER\[3\]
+ VDD VSS sg13g2_and4_1
Xplace525 net524 afe_controller_inst.AFE_CRTL_OUTPUTS\[1\]
+ VDD VSS sg13g2_buf_1
Xplace524 net523 net524 VDD VSS sg13g2_buf_1
Xplace522 net521 net522 VDD VSS sg13g2_buf_1
X_1243_ _0782_ main_fsm_top_inst.MAIN_TOP_OUTPUTS\[3\] main_fsm_top_inst.spi_dout_rdy_sig
+ VDD VSS sg13g2_nand2b_1
Xplace521 net520 net522 VDD VSS sg13g2_buf_1
X_1245_ _0784_ main_fsm_top_inst.MAIN_TOP_OUTPUTS\[4\] main_fsm_top_inst.spi_dout_rdy_sig
+ VDD VSS sg13g2_nand2_1
X_1246_ _0785_ _0778_ _0782_ _0784_ VDD VSS sg13g2_o21ai_1
Xplace523 net522 afe_controller_inst.AFE_CRTL_OUTPUTS\[2\]
+ VDD VSS sg13g2_buf_1
X_1248_ _0787_ main_fsm_top_inst.spi_rx.data_rg\[7\] main_fsm_top_inst.spi_top_inst.spi_reg.bit_cell7.VALUE_OUT
+ net508 VDD VSS sg13g2_mux2_1
X_1249_ _0788_ _0785_ _0787_ VDD VSS sg13g2_nor2_1
X_1250_ _0789_ main_fsm_top_inst.MAIN_TOP_OUTPUTS\[8\] VDD
+ VSS sg13g2_inv_1
X_1251_ _0790_ main_fsm_top_inst.MAIN_TOP_OUTPUTS\[9\] VDD
+ VSS sg13g2_inv_2
X_1252_ _0791_ net516 main_fsm_top_inst.MAIN_TOP_OUTPUTS\[7\]
+ VDD VSS sg13g2_nor2_2
X_1253_ _0792_ _0789_ net497 _0791_ VDD VSS sg13g2_nand3_1
X_1254_ _0793_ _0763_ _0785_ _0792_ VDD VSS sg13g2_a21oi_1
X_1255_ _0794_ _0788_ _0793_ VDD VSS sg13g2_nor2b_1
X_1256_ _0795_ main_fsm_top_inst.MAIN_TOP_OUTPUTS\[7\] VDD
+ VSS sg13g2_inv_1
X_1257_ _0796_ _0795_ _0789_ net497 VDD VSS sg13g2_nand3_1
X_1258_ _0797_ _0795_ _0789_ _0796_ VDD VSS sg13g2_o21ai_1
X_1259_ _0798_ afe_controller_inst.CONFIG_VALID _0785_ VDD
+ VSS sg13g2_nor2_1
X_1260_ _0799_ _0789_ net497 _0798_ VDD VSS sg13g2_nor3_1
X_1261_ _0800_ _0797_ _0799_ VDD VSS sg13g2_nor2_1
X_1262_ _0801_ net516 _0794_ _0800_ VDD VSS sg13g2_nor3_1
X_1263_ _0802_ net516 _0776_ _0801_ VDD VSS sg13g2_a21o_1
X_1264_ _0803_ afe_controller_inst.CONFIG_VALUES\[3\] VDD
+ VSS sg13g2_inv_1
X_1265_ _0804_ _0636_ _0641_ VDD VSS sg13g2_nor2_1
X_1266_ _0805_ _0803_ _0659_ _0804_ VDD VSS sg13g2_a21oi_1
X_1267_ _0806_ net526 _0805_ VDD VSS sg13g2_xnor2_1
X_1268_ _0807_ _0665_ _0714_ VDD VSS sg13g2_nor2_1
X_1269_ _0808_ net516 net497 VDD VSS sg13g2_nand2_1
Xplace520 net519 afe_controller_inst.AFE_CRTL_OUTPUTS\[3\]
+ VDD VSS sg13g2_buf_1
X_1271_ _0810_ net512 net511 _0791_ _0798_ VDD VSS sg13g2_nand4_1
X_1272_ _0811_ net514 _0808_ _0810_ VDD VSS sg13g2_o21ai_1
X_1273_ _0812_ main_fsm_top_inst.MAIN_TOP_OUTPUTS\[3\] main_fsm_top_inst.spi_dout_rdy_sig
+ VDD VSS sg13g2_nand2_1
X_1274_ _0813_ main_fsm_top_inst.MAIN_TOP_OUTPUTS\[3\] VDD
+ VSS sg13g2_inv_1
X_1275_ _0814_ _0813_ _0778_ VDD VSS sg13g2_nand2_1
X_1276_ _0815_ _0812_ _0814_ main_fsm_top_inst.MAIN_TOP_OUTPUTS\[4\]
+ VDD VSS sg13g2_a21oi_1
X_1277_ _0816_ main_fsm_top_inst.MAIN_TOP_OUTPUTS\[7\] afe_controller_inst.CONFIG_VALID
+ VDD VSS sg13g2_nor2b_1
X_1278_ _0817_ net512 _0816_ net515 VDD VSS sg13g2_o21ai_1
X_1279_ _0818_ main_fsm_top_inst.MAIN_TOP_OUTPUTS\[7\] afe_controller_inst.CONFIG_VALID
+ net512 VDD VSS sg13g2_o21ai_1
X_1280_ _0819_ _0817_ _0818_ net497 VDD VSS sg13g2_a21oi_1
X_1281_ _0820_ net516 net514 VDD VSS sg13g2_nand2_1
Xclkbuf_leaf_12_CLK clknet_leaf_12_CLK clknet_3_3__leaf_CLK
+ VDD VSS sg13g2_buf_16
X_1283_ _0822_ _0775_ _0820_ main_fsm_top_inst.spi_tx.bypass_rg
+ VDD VSS sg13g2_o21ai_1
X_1284_ _0823_ main_fsm_top_inst.MAIN_TOP_OUTPUTS\[1\] VDD
+ VSS sg13g2_inv_1
X_1285_ _0824_ main_fsm_top_inst.spi_top_inst.sck_sync main_fsm_top_inst.spi_top_inst.edge_dummy
+ VDD VSS sg13g2_nand2b_1
Xplace519 net518 afe_controller_inst.AFE_CRTL_OUTPUTS\[4\]
+ VDD VSS sg13g2_buf_1
X_1287_ _0826_ _0823_ _0824_ VDD VSS sg13g2_nand2_1
X_1288_ _0827_ _0822_ _0826_ main_fsm_top_inst.MAIN_TOP_OUTPUTS\[0\]
+ VDD VSS sg13g2_o21ai_1
X_1289_ _0828_ main_fsm_top_inst.spi_top_inst.counter_module.COUNTER\[3\]
+ VDD VSS sg13g2_inv_1
X_1290_ _0829_ main_fsm_top_inst.spi_top_inst.counter_module.COUNTER\[0\]
+ main_fsm_top_inst.spi_top_inst.counter_module.COUNTER\[1\]
+ main_fsm_top_inst.spi_top_inst.counter_module.COUNTER\[2\]
+ VDD VSS sg13g2_nand3_1
X_1291_ _0830_ main_fsm_top_inst.MAIN_TOP_OUTPUTS\[1\] main_fsm_top_inst.MAIN_TOP_OUTPUTS\[0\]
+ _0828_ _0829_ VDD VSS sg13g2_nor4_1
X_1292_ _0831_ main_fsm_top_inst.spi_top_inst.edge_dummy main_fsm_top_inst.spi_top_inst.sck_sync
+ VDD VSS sg13g2_nand2b_1
X_1293_ _0832_ _0755_ _0831_ _0823_ VDD VSS sg13g2_a21oi_1
X_1294_ _0833_ main_fsm_top_inst.MAIN_TOP_OUTPUTS\[4\] VDD
+ VSS sg13g2_inv_1
Xplace518 net517 net518 VDD VSS sg13g2_buf_1
X_1296_ _0835_ main_fsm_top_inst.MAIN_TOP_OUTPUTS\[4\] net509
+ VDD VSS sg13g2_nand2b_1
X_1297_ _0836_ _0813_ _0833_ _0831_ _0835_ VDD VSS sg13g2_a22oi_1
X_1298_ _0837_ main_fsm_top_inst.MAIN_TOP_OUTPUTS\[6\] net513
+ VDD VSS sg13g2_nor2_1
X_1299_ _0838_ net520 net519 net517 VDD VSS sg13g2_o21ai_1
X_1300_ _0839_ _0795_ _0837_ _0838_ VDD VSS sg13g2_o21ai_1
X_1301_ _0840_ _0830_ _0832_ _0836_ _0839_ VDD VSS sg13g2_nor4_1
X_1302_ _0841_ _0819_ _0827_ _0840_ VDD VSS sg13g2_nand3b_1
X_1303_ _0842_ net526 _0676_ net523 VDD VSS sg13g2_a21oi_1
X_1304_ _0843_ net523 _0673_ _0842_ VDD VSS sg13g2_a21oi_1
X_1305_ _0844_ _0792_ _0785_ VDD VSS sg13g2_nor2_1
X_1306_ _0845_ _0815_ _0841_ _0843_ _0844_ VDD VSS sg13g2_or4_1
X_1307_ _0846_ net523 _0671_ _0718_ VDD VSS sg13g2_a21oi_1
X_1308_ _0847_ _0633_ _0715_ VDD VSS sg13g2_and2_1
X_1309_ _0848_ net518 _0637_ _0846_ _0847_ VDD VSS sg13g2_nor4_1
X_1310_ _0849_ afe_controller_inst.CONFIG_VALUES\[2\] _0803_
+ VDD VSS sg13g2_nor2_1
X_1311_ _0850_ net517 net523 VDD VSS sg13g2_xor2_1
X_1312_ _0851_ _0849_ _0659_ _0688_ _0850_ net519 VDD VSS
+ sg13g2_a221oi_1
X_1313_ _0852_ _0703_ net520 VDD VSS sg13g2_nand2b_1
X_1314_ _0853_ _0848_ _0851_ _0852_ VDD VSS sg13g2_o21ai_1
X_1315_ _0854_ _0807_ _0811_ _0845_ _0853_ VDD VSS sg13g2_or4_1
X_1316_ _0855_ _0806_ _0854_ VDD VSS sg13g2_nor2_1
X_1317_ _0013_ _0802_ _0855_ _0191_ VDD VSS sg13g2_a21oi_1
Xclkbuf_leaf_8_CLK clknet_leaf_8_CLK clknet_3_2__leaf_CLK
+ VDD VSS sg13g2_buf_16
X_1319_ _0014_ net553 serializer_inst.fake_adc.sipo_flip_flops\[0\]
+ VDD VSS sg13g2_nor2b_1
X_1320_ _0015_ net558 net237 VDD VSS sg13g2_nor2b_1
Xclkbuf_leaf_11_CLK clknet_leaf_11_CLK clknet_3_3__leaf_CLK
+ VDD VSS sg13g2_buf_16
X_1322_ _0858_ main_fsm_top_inst.spi_top_inst.edge_dummy main_fsm_top_inst.spi_top_inst.sck_sync
+ VDD VSS sg13g2_nor2b_1
Xplace516 net515 net516 VDD VSS sg13g2_buf_1
Xplace517 net516 main_fsm_top_inst.MAIN_TOP_OUTPUTS\[6\] VDD
+ VSS sg13g2_buf_1
X_1325_ _0861_ _0833_ _0858_ net567 VDD VSS sg13g2_o21ai_1
Xplace515 net514 main_fsm_top_inst.MAIN_TOP_OUTPUTS\[7\] VDD
+ VSS sg13g2_buf_1
X_1327_ _0863_ net567 _0778_ main_fsm_top_inst.MAIN_TOP_OUTPUTS\[3\]
+ VDD VSS sg13g2_a21oi_1
X_1328_ _0864_ main_fsm_top_inst.MAIN_TOP_OUTPUTS\[4\] net509
+ _0863_ VDD VSS sg13g2_nor3_1
X_1329_ _0865_ main_fsm_top_inst.MAIN_TOP_OUTPUTS\[3\] _0861_
+ _0864_ VDD VSS sg13g2_a21oi_1
X_1330_ _0016_ net557 _0865_ VDD VSS sg13g2_nor2_1
X_1331_ _0866_ main_fsm_top_inst.MAIN_TOP_OUTPUTS\[0\] _0778_
+ _0823_ VDD VSS sg13g2_o21ai_1
X_1332_ _0867_ _0866_ VDD VSS sg13g2_inv_1
X_1333_ _0868_ main_fsm_top_inst.spi_top_inst.sck_sync main_fsm_top_inst.spi_top_inst.edge_dummy
+ VDD VSS sg13g2_nor2b_1
Xplace513 net512 net513 VDD VSS sg13g2_buf_1
X_1335_ _0870_ main_fsm_top_inst.MAIN_TOP_OUTPUTS\[0\] _0868_
+ _0822_ VDD VSS sg13g2_a21oi_1
X_1336_ _0871_ net564 _0867_ _0870_ VDD VSS sg13g2_nand3_1
X_1337_ _0872_ net533 main_fsm_top_inst.MAIN_TOP_OUTPUTS\[0\]
+ VDD VSS sg13g2_nand2_1
Xclkbuf_leaf_7_CLK clknet_leaf_7_CLK clknet_3_2__leaf_CLK
+ VDD VSS sg13g2_buf_16
Xplace512 net511 main_fsm_top_inst.MAIN_TOP_OUTPUTS\[9\] VDD
+ VSS sg13g2_buf_1
X_1340_ _0017_ _0871_ _0872_ net562 VDD VSS sg13g2_a21oi_1
Xplace514 net513 main_fsm_top_inst.MAIN_TOP_OUTPUTS\[8\] VDD
+ VSS sg13g2_buf_1
Xplace511 net510 main_fsm_top_inst.Register_File_inst.r_addr\[0\]
+ VDD VSS sg13g2_buf_1
X_1343_ _0877_ afe_controller_inst.AFE_CRTL_OUTPUTS\[10\]
+ net502 VDD VSS sg13g2_nand2_1
Xclkbuf_leaf_6_CLK clknet_leaf_6_CLK clknet_3_2__leaf_CLK
+ VDD VSS sg13g2_buf_16
X_1345_ _0879_ net500 serializer_inst.piso.piso_flip_flops\[19\]
+ VDD VSS sg13g2_nand2b_1
X_1346_ _0018_ _0877_ _0879_ net557 VDD VSS sg13g2_a21oi_1
X_1347_ _0880_ net498 afe_controller_inst.AFE_CRTL_OUTPUTS\[9\]
+ VDD VSS sg13g2_nand2_1
X_1348_ _0881_ net500 serializer_inst.piso.piso_flip_flops\[18\]
+ VDD VSS sg13g2_nand2b_1
X_1349_ _0019_ _0880_ _0881_ net558 VDD VSS sg13g2_a21oi_1
X_1350_ _0882_ afe_controller_inst.AFE_CRTL_OUTPUTS\[8\] net498
+ VDD VSS sg13g2_nand2_1
X_1351_ _0883_ net500 serializer_inst.piso.piso_flip_flops\[17\]
+ VDD VSS sg13g2_nand2b_1
Xclkbuf_leaf_4_CLK clknet_leaf_4_CLK clknet_3_3__leaf_CLK
+ VDD VSS sg13g2_buf_16
X_1353_ _0020_ _0882_ _0883_ net558 VDD VSS sg13g2_a21oi_1
X_1354_ _0885_ net498 afe_controller_inst.AFE_CRTL_OUTPUTS\[7\]
+ VDD VSS sg13g2_nand2_1
X_1355_ _0886_ net498 serializer_inst.piso.piso_flip_flops\[16\]
+ VDD VSS sg13g2_nand2b_1
X_1356_ _0021_ _0885_ _0886_ net558 VDD VSS sg13g2_a21oi_1
X_1357_ _0887_ net498 afe_controller_inst.AFE_CRTL_OUTPUTS\[6\]
+ VDD VSS sg13g2_nand2_1
X_1358_ _0888_ net498 serializer_inst.piso.piso_flip_flops\[15\]
+ VDD VSS sg13g2_nand2b_1
X_1359_ _0022_ _0887_ _0888_ net559 VDD VSS sg13g2_a21oi_1
X_1360_ _0889_ net498 adc_ready_out_sig VDD VSS sg13g2_nand2_1
X_1361_ _0890_ net498 serializer_inst.piso.piso_flip_flops\[14\]
+ VDD VSS sg13g2_nand2b_1
X_1362_ _0023_ _0889_ _0890_ net559 VDD VSS sg13g2_a21oi_1
Xplace509 net508 net509 VDD VSS sg13g2_buf_1
X_1364_ _0892_ net518 net499 VDD VSS sg13g2_nand2_1
X_1365_ _0893_ net500 serializer_inst.piso.piso_flip_flops\[13\]
+ VDD VSS sg13g2_nand2b_1
X_1366_ _0024_ _0892_ _0893_ net559 VDD VSS sg13g2_a21oi_1
X_1367_ _0894_ afe_controller_inst.AFE_CRTL_OUTPUTS\[3\] net499
+ VDD VSS sg13g2_nand2_1
X_1368_ _0895_ net500 serializer_inst.piso.piso_flip_flops\[12\]
+ VDD VSS sg13g2_nand2b_1
X_1369_ _0025_ _0894_ _0895_ net558 VDD VSS sg13g2_a21oi_1
X_1370_ _0896_ net521 net499 VDD VSS sg13g2_nand2_1
Xclkbuf_leaf_5_CLK clknet_leaf_5_CLK clknet_3_2__leaf_CLK
+ VDD VSS sg13g2_buf_16
X_1372_ _0898_ net500 serializer_inst.piso.piso_flip_flops\[11\]
+ VDD VSS sg13g2_nand2b_1
X_1373_ _0026_ _0896_ _0898_ net559 VDD VSS sg13g2_a21oi_1
X_1374_ _0899_ afe_controller_inst.AFE_CRTL_OUTPUTS\[1\] net499
+ VDD VSS sg13g2_nand2_1
X_1375_ _0900_ net500 serializer_inst.piso.piso_flip_flops\[10\]
+ VDD VSS sg13g2_nand2b_1
X_1376_ _0027_ _0899_ _0900_ net559 VDD VSS sg13g2_a21oi_1
X_1377_ _0901_ net525 net499 VDD VSS sg13g2_nand2_1
X_1378_ _0902_ net500 serializer_inst.piso.piso_flip_flops\[9\]
+ VDD VSS sg13g2_nand2b_1
X_1379_ _0028_ _0901_ _0902_ net559 VDD VSS sg13g2_a21oi_1
X_1380_ _0903_ net511 net502 VDD VSS sg13g2_nand2_1
X_1381_ _0904_ serializer_inst.freeze_delay serializer_inst.piso.piso_flip_flops\[8\]
+ VDD VSS sg13g2_nand2b_1
X_1382_ _0029_ _0903_ _0904_ net559 VDD VSS sg13g2_a21oi_1
X_1383_ _0905_ net512 net501 VDD VSS sg13g2_nand2_1
X_1384_ _0906_ net501 serializer_inst.piso.piso_flip_flops\[7\]
+ VDD VSS sg13g2_nand2b_1
Xplace537 net536 net544 VDD VSS sg13g2_buf_1
X_1386_ _0030_ _0905_ _0906_ net560 VDD VSS sg13g2_a21oi_1
X_1387_ _0908_ main_fsm_top_inst.MAIN_TOP_OUTPUTS\[7\] net501
+ VDD VSS sg13g2_nand2_1
X_1388_ _0909_ net501 serializer_inst.piso.piso_flip_flops\[6\]
+ VDD VSS sg13g2_nand2b_1
X_1389_ _0031_ _0908_ _0909_ net561 VDD VSS sg13g2_a21oi_1
X_1390_ _0910_ net515 net501 VDD VSS sg13g2_nand2_1
X_1391_ _0911_ serializer_inst.freeze_delay serializer_inst.piso.piso_flip_flops\[5\]
+ VDD VSS sg13g2_nand2b_1
X_1392_ _0032_ _0910_ _0911_ net561 VDD VSS sg13g2_a21oi_1
X_1393_ _0912_ net502 main_fsm_top_inst.MAIN_TOP_OUTPUTS\[4\]
+ VDD VSS sg13g2_nand2_1
X_1394_ _0913_ serializer_inst.freeze_delay serializer_inst.piso.piso_flip_flops\[3\]
+ VDD VSS sg13g2_nand2b_1
X_1395_ _0033_ _0912_ _0913_ net560 VDD VSS sg13g2_a21oi_1
X_1396_ _0914_ main_fsm_top_inst.MAIN_TOP_OUTPUTS\[3\] net502
+ VDD VSS sg13g2_nand2_1
X_1397_ _0915_ net502 serializer_inst.piso.piso_flip_flops\[2\]
+ VDD VSS sg13g2_nand2b_1
X_1398_ _0034_ _0914_ _0915_ net560 VDD VSS sg13g2_a21oi_1
X_1399_ _0916_ net502 serializer_inst.piso.piso_flip_flops\[1\]
+ VDD VSS sg13g2_nor2_1
X_1400_ _0035_ net560 _0916_ VDD VSS sg13g2_nor2_1
X_1401_ _0917_ main_fsm_top_inst.MAIN_TOP_OUTPUTS\[1\] net501
+ VDD VSS sg13g2_nand2_1
X_1402_ _0918_ net501 serializer_inst.piso.piso_flip_flops\[0\]
+ VDD VSS sg13g2_nand2b_1
X_1403_ _0036_ _0917_ _0918_ net561 VDD VSS sg13g2_a21oi_1
Xplace510 net509 main_fsm_top_inst.spi_dout_rdy_sig VDD VSS
+ sg13g2_buf_1
X_1405_ _0920_ serializer_inst.fake_adc.sipo_flip_flops\[6\]
+ net503 VDD VSS sg13g2_nand2_1
X_1406_ _0921_ net503 serializer_inst.fake_adc.skid.data_rg\[6\]
+ VDD VSS sg13g2_nand2b_1
X_1407_ _0922_ afe_controller_inst.fifo_in_sel\[1\] afe_controller_inst.fifo_in_sel\[0\]
+ VDD VSS sg13g2_nand2b_1
X_1408_ _0923_ _0920_ _0921_ _0922_ VDD VSS sg13g2_a21oi_1
X_1409_ _0924_ afe_controller_inst.fifo.WE VDD VSS sg13g2_inv_1
X_1410_ _0925_ _0658_ _0653_ _0924_ VDD VSS sg13g2_a21oi_2
X_1411_ _0926_ afe_controller_inst.fifo.w_ptr\[0\] _0765_
+ VDD VSS sg13g2_nor2_1
X_1412_ _0927_ _0925_ _0926_ VDD VSS sg13g2_nand2_1
X_1413_ _0928_ net527 net556 _0927_ VDD VSS sg13g2_nor3_2
X_1414_ _0929_ _0923_ _0928_ VDD VSS sg13g2_nand2_1
X_1415_ _0930_ net527 VDD VSS sg13g2_inv_1
X_1416_ _0931_ net556 VDD VSS sg13g2_inv_1
Xplace508 net507 afe_controller_inst.CONFIG_VALID VDD VSS
+ sg13g2_buf_1
X_1418_ _0933_ _0930_ _0931_ _0925_ _0926_ VDD VSS sg13g2_nand4_1
Xclkbuf_leaf_14_CLK clknet_leaf_14_CLK clknet_3_6__leaf_CLK
+ VDD VSS sg13g2_buf_16
X_1420_ _0935_ net565 afe_controller_inst.clear net556 VDD
+ VSS sg13g2_a21oi_1
Xclkbuf_leaf_13_CLK clknet_leaf_13_CLK clknet_3_6__leaf_CLK
+ VDD VSS sg13g2_buf_16
Xclkbuf_leaf_19_CLK clknet_leaf_19_CLK clknet_3_7__leaf_CLK
+ VDD VSS sg13g2_buf_16
X_1423_ _0938_ afe_controller_inst.fifo.mem\[0\]\[6\] net482
+ net490 VDD VSS sg13g2_nand3_1
X_1424_ _0037_ _0929_ _0938_ VDD VSS sg13g2_nand2_1
X_1425_ _0939_ serializer_inst.fake_adc.sipo_flip_flops\[5\]
+ net503 VDD VSS sg13g2_nand2_1
X_1426_ _0940_ net503 serializer_inst.fake_adc.skid.data_rg\[5\]
+ VDD VSS sg13g2_nand2b_1
X_1427_ _0941_ _0939_ _0940_ _0922_ VDD VSS sg13g2_a21oi_1
X_1428_ _0942_ _0928_ _0941_ VDD VSS sg13g2_nand2_1
X_1429_ _0943_ afe_controller_inst.fifo.mem\[0\]\[5\] net482
+ net490 VDD VSS sg13g2_nand3_1
X_1430_ _0038_ _0942_ _0943_ VDD VSS sg13g2_nand2_1
X_1431_ _0944_ serializer_inst.fake_adc.sipo_flip_flops\[4\]
+ net503 VDD VSS sg13g2_nand2_1
X_1432_ _0945_ net503 serializer_inst.fake_adc.skid.data_rg\[4\]
+ VDD VSS sg13g2_nand2b_1
X_1433_ _0946_ _0944_ _0945_ _0922_ VDD VSS sg13g2_a21oi_1
X_1434_ _0947_ _0928_ _0946_ VDD VSS sg13g2_nand2_1
X_1435_ _0948_ afe_controller_inst.fifo.mem\[0\]\[4\] net482
+ net490 VDD VSS sg13g2_nand3_1
X_1436_ _0039_ _0947_ _0948_ VDD VSS sg13g2_nand2_1
X_1437_ _0949_ serializer_inst.fake_adc.sipo_flip_flops\[3\]
+ net504 VDD VSS sg13g2_nand2_1
X_1438_ _0950_ net504 serializer_inst.fake_adc.skid.data_rg\[3\]
+ VDD VSS sg13g2_nand2b_1
X_1439_ _0951_ _0949_ _0950_ _0922_ VDD VSS sg13g2_a21oi_1
X_1440_ _0952_ _0928_ _0951_ VDD VSS sg13g2_nand2_1
X_1441_ _0953_ afe_controller_inst.fifo.mem\[0\]\[3\] net482
+ net492 VDD VSS sg13g2_nand3_1
X_1442_ _0040_ _0952_ _0953_ VDD VSS sg13g2_nand2_1
X_1443_ _0954_ serializer_inst.fake_adc.sipo_flip_flops\[2\]
+ net504 VDD VSS sg13g2_nand2_1
X_1444_ _0955_ net504 serializer_inst.fake_adc.skid.data_rg\[2\]
+ VDD VSS sg13g2_nand2b_1
X_1445_ _0956_ _0954_ _0955_ _0922_ VDD VSS sg13g2_a21oi_1
X_1446_ _0957_ _0928_ _0956_ VDD VSS sg13g2_nand2_1
X_1447_ _0958_ afe_controller_inst.fifo.mem\[0\]\[2\] net482
+ net492 VDD VSS sg13g2_nand3_1
X_1448_ _0041_ _0957_ _0958_ VDD VSS sg13g2_nand2_1
X_1449_ _0959_ afe_controller_inst.fifo_in_sel\[1\] afe_controller_inst.fifo_in_sel\[0\]
+ VDD VSS sg13g2_nor2b_1
X_1450_ _0960_ afe_controller_inst.fifo_in_sel\[0\] afe_controller_inst.fifo_in_sel\[1\]
+ VDD VSS sg13g2_nor2b_1
X_1451_ _0961_ serializer_inst.fake_adc.sipo_flip_flops\[1\]
+ _0959_ _0960_ serializer_inst.fake_adc.sipo_flip_flops\[9\]
+ VDD VSS sg13g2_a22oi_1
X_1452_ _0962_ serializer_inst.fake_adc.skid.data_rg\[1\]
+ _0959_ _0960_ serializer_inst.fake_adc.skid.data_rg\[9\] net504
+ VDD VSS sg13g2_a221oi_1
X_1453_ _0963_ net504 _0961_ _0962_ VDD VSS sg13g2_a21o_1
Xclkbuf_leaf_10_CLK clknet_leaf_10_CLK clknet_3_3__leaf_CLK
+ VDD VSS sg13g2_buf_16
X_1455_ _0965_ afe_controller_inst.fifo.mem\[0\]\[1\] _0933_
+ net489 VDD VSS sg13g2_nand3_1
X_1456_ _0042_ _0933_ _0963_ _0965_ VDD VSS sg13g2_o21ai_1
X_1457_ _0966_ serializer_inst.fake_adc.skid.data_rg\[0\]
+ serializer_inst.fake_adc.sipo_flip_flops\[0\] serializer_inst.fake_adc.skid.bypass_rg
+ VDD VSS sg13g2_mux2_1
X_1458_ _0967_ serializer_inst.fake_adc.skid.data_rg\[8\]
+ serializer_inst.fake_adc.sipo_flip_flops\[8\] net504 VDD VSS
+ sg13g2_mux2_1
X_1459_ _0968_ _0959_ _0966_ _0967_ _0960_ VDD VSS sg13g2_a22oi_1
X_1460_ _0969_ afe_controller_inst.fifo.mem\[0\]\[0\] net482
+ _0935_ VDD VSS sg13g2_nand3_1
X_1461_ _0043_ net482 _0968_ _0969_ VDD VSS sg13g2_o21ai_1
X_1462_ _0970_ afe_controller_inst.fifo.w_ptr\[0\] _0925_
+ VDD VSS sg13g2_nand2_2
X_1463_ _0971_ net527 net556 _0765_ _0970_ VDD VSS sg13g2_nor4_2
X_1464_ _0972_ _0923_ _0971_ VDD VSS sg13g2_nand2_1
Xclkbuf_leaf_9_CLK clknet_leaf_9_CLK clknet_3_2__leaf_CLK
+ VDD VSS sg13g2_buf_16
X_1466_ _0974_ net527 net556 _0765_ _0970_ VDD VSS sg13g2_or4_1
Xplace507 net506 main_fsm_top_inst.spi_tx.bypass_rg VDD VSS
+ sg13g2_buf_1
X_1468_ _0976_ afe_controller_inst.fifo.mem\[1\]\[6\] net491
+ net476 VDD VSS sg13g2_nand3_1
X_1469_ _0044_ _0972_ _0976_ VDD VSS sg13g2_nand2_1
X_1470_ _0977_ _0941_ _0971_ VDD VSS sg13g2_nand2_1
X_1471_ _0978_ afe_controller_inst.fifo.mem\[1\]\[5\] net491
+ net476 VDD VSS sg13g2_nand3_1
X_1472_ _0045_ _0977_ _0978_ VDD VSS sg13g2_nand2_1
X_1473_ _0979_ _0946_ _0971_ VDD VSS sg13g2_nand2_1
X_1474_ _0980_ afe_controller_inst.fifo.mem\[1\]\[4\] net490
+ net476 VDD VSS sg13g2_nand3_1
X_1475_ _0046_ _0979_ _0980_ VDD VSS sg13g2_nand2_1
X_1476_ _0981_ _0951_ _0971_ VDD VSS sg13g2_nand2_1
X_1477_ _0982_ afe_controller_inst.fifo.mem\[1\]\[3\] net492
+ net476 VDD VSS sg13g2_nand3_1
X_1478_ _0047_ _0981_ _0982_ VDD VSS sg13g2_nand2_1
X_1479_ _0983_ _0956_ _0971_ VDD VSS sg13g2_nand2_1
X_1480_ _0984_ afe_controller_inst.fifo.mem\[1\]\[2\] net492
+ net476 VDD VSS sg13g2_nand3_1
X_1481_ _0048_ _0983_ _0984_ VDD VSS sg13g2_nand2_1
X_1482_ _0985_ afe_controller_inst.fifo.mem\[1\]\[1\] net489
+ _0974_ VDD VSS sg13g2_nand3_1
X_1483_ _0049_ _0963_ _0974_ _0985_ VDD VSS sg13g2_o21ai_1
X_1484_ _0986_ afe_controller_inst.fifo.mem\[1\]\[0\] _0935_
+ net476 VDD VSS sg13g2_nand3_1
X_1485_ _0050_ _0968_ net476 _0986_ VDD VSS sg13g2_o21ai_1
X_1486_ _0987_ net527 _0931_ VDD VSS sg13g2_nand2_1
X_1487_ _0988_ _0927_ _0987_ VDD VSS sg13g2_nor2_1
X_1488_ _0989_ _0923_ _0988_ VDD VSS sg13g2_nand2_1
X_1489_ _0990_ _0927_ _0987_ VDD VSS sg13g2_or2_1
Xplace506 net505 main_fsm_top_inst.spi_tx.bypass_rg VDD VSS
+ sg13g2_buf_1
X_1491_ _0992_ afe_controller_inst.fifo.mem\[2\]\[6\] net490
+ net475 VDD VSS sg13g2_nand3_1
X_1492_ _0051_ _0989_ _0992_ VDD VSS sg13g2_nand2_1
X_1493_ _0993_ _0941_ _0988_ VDD VSS sg13g2_nand2_1
X_1494_ _0994_ afe_controller_inst.fifo.mem\[2\]\[5\] net490
+ net475 VDD VSS sg13g2_nand3_1
X_1495_ _0052_ _0993_ _0994_ VDD VSS sg13g2_nand2_1
X_1496_ _0995_ _0946_ _0988_ VDD VSS sg13g2_nand2_1
X_1497_ _0996_ afe_controller_inst.fifo.mem\[2\]\[4\] _0935_
+ net475 VDD VSS sg13g2_nand3_1
X_1498_ _0053_ _0995_ _0996_ VDD VSS sg13g2_nand2_1
X_1499_ _0997_ _0951_ _0988_ VDD VSS sg13g2_nand2_1
X_1500_ _0998_ afe_controller_inst.fifo.mem\[2\]\[3\] net492
+ net475 VDD VSS sg13g2_nand3_1
X_1501_ _0054_ _0997_ _0998_ VDD VSS sg13g2_nand2_1
X_1502_ _0999_ net514 _0789_ VDD VSS sg13g2_nand2_1
X_1503_ _1000_ main_fsm_top_inst.MAIN_TOP_OUTPUTS\[9\] _0837_
+ _0999_ VDD VSS sg13g2_o21ai_1
Xplace504 net503 net504 VDD VSS sg13g2_buf_1
X_1505_ _1002_ main_fsm_top_inst.MAIN_TOP_OUTPUTS\[6\] net514
+ VDD VSS sg13g2_nand2b_1
X_1506_ _1003_ _0775_ _1002_ VDD VSS sg13g2_nor2_1
X_1507_ _1004_ main_fsm_top_inst.spi_rx.data_rg\[2\] main_fsm_top_inst.spi_top_inst.spi_reg.bit_cell2.VALUE_OUT
+ net509 VDD VSS sg13g2_mux2_1
X_1508_ _1005_ _0795_ net513 VDD VSS sg13g2_nand2_1
X_1509_ _1006_ main_fsm_top_inst.MAIN_TOP_OUTPUTS\[6\] net497
+ _1005_ _0999_ VDD VSS sg13g2_nand4_1
X_1510_ _1007_ _1003_ _1006_ VDD VSS sg13g2_nand2b_1
Xplace499 net498 net499 VDD VSS sg13g2_buf_1
X_1512_ _1009_ net510 main_fsm_top_inst.Register_File_inst.r_addr\[1\]
+ VDD VSS sg13g2_nand2_1
X_1513_ _1010_ main_fsm_top_inst.Register_File_inst.r_addr\[2\]
+ _1007_ _1009_ VDD VSS sg13g2_nor3_1
X_1514_ _1011_ _1003_ _1004_ _1010_ VDD VSS sg13g2_a21o_1
X_1515_ _1012_ main_fsm_top_inst.Register_File_inst.r_addr\[0\]
+ main_fsm_top_inst.Register_File_inst.r_addr\[1\] VDD VSS sg13g2_and2_1
X_1516_ _1013_ _1007_ _1012_ _1000_ VDD VSS sg13g2_o21ai_1
X_1517_ _1014_ _1000_ _1011_ _1013_ main_fsm_top_inst.Register_File_inst.r_addr\[2\]
+ VDD VSS sg13g2_a22oi_1
X_1518_ _0055_ net534 _1014_ VDD VSS sg13g2_nor2_1
X_1519_ _1015_ _0956_ _0988_ VDD VSS sg13g2_nand2_1
X_1520_ _1016_ afe_controller_inst.fifo.mem\[2\]\[2\] net492
+ net475 VDD VSS sg13g2_nand3_1
X_1521_ _0056_ _1015_ _1016_ VDD VSS sg13g2_nand2_1
X_1522_ _1017_ afe_controller_inst.fifo.mem\[2\]\[1\] net489
+ _0990_ VDD VSS sg13g2_nand3_1
X_1523_ _0057_ _0963_ _0990_ _1017_ VDD VSS sg13g2_o21ai_1
X_1524_ _1018_ afe_controller_inst.fifo.mem\[2\]\[0\] net489
+ net475 VDD VSS sg13g2_nand3_1
X_1525_ _0058_ _0968_ net475 _1018_ VDD VSS sg13g2_o21ai_1
X_1526_ _1019_ _0765_ _0970_ _0987_ VDD VSS sg13g2_nor3_2
Xplace498 net497 _0790_ VDD VSS sg13g2_buf_1
X_1528_ _1021_ afe_controller_inst.fifo.mem\[3\]\[6\] net491
+ VDD VSS sg13g2_nand2_1
X_1529_ _1022_ _0923_ net473 VDD VSS sg13g2_nand2_1
X_1530_ _0059_ net473 _1021_ _1022_ VDD VSS sg13g2_o21ai_1
Xplace541 net540 net541 VDD VSS sg13g2_buf_1
X_1532_ _1024_ main_fsm_top_inst.spi_top_inst.spi_reg.bit_cell7.VALUE_OUT
+ net494 VDD VSS sg13g2_nor2_1
X_1533_ _1025_ main_fsm_top_inst.spi_top_inst.load_in\[6\]
+ main_fsm_top_inst.spi_top_inst.spi_reg.bit_cell6.DATA_OUT
+ _0756_ VDD VSS sg13g2_mux2_1
X_1534_ _1026_ net495 _1025_ VDD VSS sg13g2_nor2_1
X_1535_ _0060_ net540 _1024_ _1026_ VDD VSS sg13g2_nor3_1
X_1536_ _1027_ main_fsm_top_inst.spi_top_inst.spi_reg.bit_cell6.VALUE_OUT
+ net493 VDD VSS sg13g2_nand2_1
X_1537_ _1028_ main_fsm_top_inst.spi_top_inst.spi_reg.bit_cell6.DATA_OUT
+ net496 VDD VSS sg13g2_nand2_1
X_1538_ _0061_ _1027_ _1028_ net538 VDD VSS sg13g2_a21oi_1
X_1539_ _1029_ main_fsm_top_inst.spi_top_inst.spi_reg.bit_cell6.VALUE_OUT
+ net494 VDD VSS sg13g2_nor2_1
X_1540_ _1030_ main_fsm_top_inst.spi_top_inst.load_in\[5\]
+ main_fsm_top_inst.spi_top_inst.spi_reg.bit_cell5.DATA_OUT
+ _0756_ VDD VSS sg13g2_mux2_1
X_1541_ _1031_ net495 _1030_ VDD VSS sg13g2_nor2_1
X_1542_ _0062_ net538 _1029_ _1031_ VDD VSS sg13g2_nor3_1
X_1543_ _1032_ afe_controller_inst.fifo.mem\[3\]\[5\] net490
+ VDD VSS sg13g2_nand2_1
X_1544_ _1033_ _0941_ net473 VDD VSS sg13g2_nand2_1
X_1545_ _0063_ net473 _1032_ _1033_ VDD VSS sg13g2_o21ai_1
X_1546_ _1034_ afe_controller_inst.fifo.mem\[3\]\[4\] net490
+ VDD VSS sg13g2_nand2_1
X_1547_ _1035_ _0946_ net473 VDD VSS sg13g2_nand2_1
X_1548_ _0064_ net473 _1034_ _1035_ VDD VSS sg13g2_o21ai_1
X_1549_ _1036_ main_fsm_top_inst.spi_top_inst.spi_reg.bit_cell5.VALUE_OUT
+ net493 VDD VSS sg13g2_nand2_1
X_1550_ _1037_ main_fsm_top_inst.spi_top_inst.spi_reg.bit_cell5.DATA_OUT
+ net496 VDD VSS sg13g2_nand2_1
X_1551_ _0065_ _1036_ _1037_ net542 VDD VSS sg13g2_a21oi_1
X_1552_ _1038_ main_fsm_top_inst.spi_top_inst.spi_reg.bit_cell5.VALUE_OUT
+ net494 VDD VSS sg13g2_nor2_1
X_1553_ _1039_ main_fsm_top_inst.spi_top_inst.load_in\[4\]
+ main_fsm_top_inst.spi_top_inst.spi_reg.bit_cell4.DATA_OUT
+ _0756_ VDD VSS sg13g2_mux2_1
X_1554_ _1040_ net495 _1039_ VDD VSS sg13g2_nor2_1
X_1555_ _0066_ net538 _1038_ _1040_ VDD VSS sg13g2_nor3_1
X_1556_ _1041_ afe_controller_inst.fifo.mem\[3\]\[3\] net492
+ VDD VSS sg13g2_nand2_1
X_1557_ _1042_ _0951_ net474 VDD VSS sg13g2_nand2_1
X_1558_ _0067_ net474 _1041_ _1042_ VDD VSS sg13g2_o21ai_1
X_1559_ _1043_ main_fsm_top_inst.spi_top_inst.spi_reg.bit_cell4.VALUE_OUT
+ net493 VDD VSS sg13g2_nand2_1
X_1560_ _1044_ main_fsm_top_inst.spi_top_inst.spi_reg.bit_cell4.DATA_OUT
+ net496 VDD VSS sg13g2_nand2_1
X_1561_ _0068_ _1043_ _1044_ net538 VDD VSS sg13g2_a21oi_1
X_1562_ _1045_ main_fsm_top_inst.spi_top_inst.spi_reg.bit_cell4.VALUE_OUT
+ net494 VDD VSS sg13g2_nor2_1
X_1563_ _1046_ main_fsm_top_inst.spi_top_inst.load_in\[3\]
+ main_fsm_top_inst.spi_top_inst.spi_reg.bit_cell3.DATA_OUT
+ _0756_ VDD VSS sg13g2_mux2_1
X_1564_ _1047_ net495 _1046_ VDD VSS sg13g2_nor2_1
X_1565_ _0069_ net539 _1045_ _1047_ VDD VSS sg13g2_nor3_1
X_1566_ _1048_ afe_controller_inst.fifo.mem\[3\]\[2\] net492
+ VDD VSS sg13g2_nand2_1
X_1567_ _1049_ _0956_ net474 VDD VSS sg13g2_nand2_1
X_1568_ _0070_ net474 _1048_ _1049_ VDD VSS sg13g2_o21ai_1
X_1569_ _1050_ afe_controller_inst.fifo.mem\[3\]\[1\] net489
+ VDD VSS sg13g2_nand2_1
X_1570_ _1051_ _0963_ _1019_ VDD VSS sg13g2_nand2b_1
X_1571_ _0071_ _1019_ _1050_ _1051_ VDD VSS sg13g2_o21ai_1
X_1572_ _1052_ afe_controller_inst.fifo.mem\[3\]\[0\] net489
+ VDD VSS sg13g2_nand2_1
X_1573_ _1053_ _0968_ _1019_ VDD VSS sg13g2_nand2b_1
X_1574_ _0072_ _1019_ _1052_ _1053_ VDD VSS sg13g2_o21ai_1
X_1575_ _1054_ main_fsm_top_inst.spi_top_inst.spi_reg.bit_cell3.VALUE_OUT
+ net493 VDD VSS sg13g2_nand2_1
X_1576_ _1055_ main_fsm_top_inst.spi_top_inst.spi_reg.bit_cell3.DATA_OUT
+ net496 VDD VSS sg13g2_nand2_1
X_1577_ _0073_ _1054_ _1055_ net540 VDD VSS sg13g2_a21oi_1
X_1578_ _1056_ main_fsm_top_inst.spi_top_inst.spi_reg.bit_cell3.VALUE_OUT
+ net494 VDD VSS sg13g2_nor2_1
X_1579_ _1057_ main_fsm_top_inst.spi_top_inst.load_in\[2\]
+ main_fsm_top_inst.spi_top_inst.spi_reg.bit_cell2.DATA_OUT
+ _0756_ VDD VSS sg13g2_mux2_1
X_1580_ _1058_ net495 _1057_ VDD VSS sg13g2_nor2_1
X_1581_ _0074_ net539 _1056_ _1058_ VDD VSS sg13g2_nor3_1
Xplace497 net496 _0824_ VDD VSS sg13g2_buf_1
X_1583_ _0075_ net549 main_fsm_top_inst.Register_File_inst.registers\[0\]\[6\]
+ VDD VSS sg13g2_or2_1
X_1584_ _1060_ main_fsm_top_inst.MAIN_TOP_OUTPUTS\[3\] _0778_
+ VDD VSS sg13g2_nor2_1
X_1585_ _1061_ net515 _0795_ _0775_ VDD VSS sg13g2_a21oi_1
X_1586_ _1062_ _1060_ _0835_ _1061_ VDD VSS sg13g2_nor3_1
Xplace496 net495 _0831_ VDD VSS sg13g2_buf_1
X_1588_ _1064_ main_fsm_top_inst.spi_top_inst.spi_reg.bit_cell7.VALUE_OUT
+ net486 VDD VSS sg13g2_nand2_1
X_1589_ _1065_ net486 main_fsm_top_inst.spi_rx.data_rg\[7\]
+ VDD VSS sg13g2_nand2b_1
Xclkbuf_leaf_15_CLK clknet_leaf_15_CLK clknet_3_6__leaf_CLK
+ VDD VSS sg13g2_buf_16
X_1591_ _0076_ _1064_ _1065_ net539 VDD VSS sg13g2_a21oi_1
X_1592_ _0077_ net549 main_fsm_top_inst.Register_File_inst.registers\[0\]\[5\]
+ VDD VSS sg13g2_nor2b_1
X_1593_ _0238_ main_fsm_top_inst.spi_top_inst.spi_reg.bit_cell2.VALUE_OUT
+ net493 VDD VSS sg13g2_nand2_1
X_1594_ _0239_ main_fsm_top_inst.spi_top_inst.spi_reg.bit_cell2.DATA_OUT
+ net496 VDD VSS sg13g2_nand2_1
X_1595_ _0078_ _0238_ _0239_ net540 VDD VSS sg13g2_a21oi_1
X_1596_ _0079_ net535 main_fsm_top_inst.Register_File_inst.registers\[0\]\[4\]
+ VDD VSS sg13g2_or2_1
X_1597_ _0080_ net550 main_fsm_top_inst.Register_File_inst.registers\[0\]\[3\]
+ VDD VSS sg13g2_nor2b_1
X_1598_ _0081_ net552 main_fsm_top_inst.Register_File_inst.registers\[0\]\[2\]
+ VDD VSS sg13g2_or2_1
X_1599_ _0082_ net536 main_fsm_top_inst.Register_File_inst.registers\[0\]\[1\]
+ VDD VSS sg13g2_or2_1
X_1600_ _0083_ net551 main_fsm_top_inst.Register_File_inst.registers\[0\]\[0\]
+ VDD VSS sg13g2_or2_1
Xclkbuf_leaf_17_CLK clknet_leaf_17_CLK clknet_3_7__leaf_CLK
+ VDD VSS sg13g2_buf_16
X_1602_ _0241_ net549 main_fsm_top_inst.Register_File_inst.registers\[1\]\[6\]
+ VDD VSS sg13g2_nor2b_1
X_1603_ _0242_ net513 _0790_ VDD VSS sg13g2_nor2_1
X_1604_ _0243_ _0242_ _0791_ VDD VSS sg13g2_nand2_1
X_1605_ _0244_ net508 VDD VSS sg13g2_inv_1
X_1606_ _0245_ main_fsm_top_inst.spi_top_inst.spi_reg.bit_cell6.VALUE_OUT
+ net508 VDD VSS sg13g2_and2_1
X_1607_ _0246_ main_fsm_top_inst.spi_rx.data_rg\[6\] _0244_
+ _0245_ VDD VSS sg13g2_a21oi_1
X_1608_ _0247_ main_fsm_top_inst.MAIN_TOP_OUTPUTS\[6\] main_fsm_top_inst.MAIN_TOP_OUTPUTS\[7\]
+ VDD VSS sg13g2_and2_1
Xplace540 net539 net540 VDD VSS sg13g2_buf_1
X_1610_ _0249_ main_fsm_top_inst.MAIN_TOP_OUTPUTS\[8\] _0247_
+ VDD VSS sg13g2_xnor2_1
X_1611_ _0250_ main_fsm_top_inst.MAIN_TOP_OUTPUTS\[9\] _0249_
+ VDD VSS sg13g2_nor2_1
Xplace505 net504 serializer_inst.fake_adc.skid.bypass_rg VDD
+ VSS sg13g2_buf_1
Xplace539 net538 net540 VDD VSS sg13g2_buf_1
Xplace538 net537 net541 VDD VSS sg13g2_buf_1
X_1615_ _0254_ afe_controller_inst.fifo.mem\[0\]\[6\] afe_controller_inst.fifo.mem\[1\]\[6\]
+ afe_controller_inst.fifo.mem\[2\]\[6\] afe_controller_inst.fifo.mem\[3\]\[6\]
+ _0007_ _0008_ VDD VSS sg13g2_mux4_1
X_1616_ _0255_ net483 _0254_ VDD VSS sg13g2_nand2_1
X_1617_ _0256_ net484 _0246_ _0255_ VDD VSS sg13g2_o21ai_1
Xplace495 net494 _0858_ VDD VSS sg13g2_buf_1
X_1619_ _0258_ _0795_ _0789_ VDD VSS sg13g2_nand2_1
X_1620_ _0259_ main_fsm_top_inst.MAIN_TOP_OUTPUTS\[6\] _0789_
+ afe_controller_inst.CONFIG_VALUES\[4\] VDD VSS sg13g2_nand3b_1
X_1621_ _0260_ net513 _0247_ VDD VSS sg13g2_nand2_1
X_1622_ _0261_ _0790_ _0258_ _0259_ _0260_ VDD VSS sg13g2_nand4_1
X_1623_ _0262_ _0243_ _0261_ net242 VDD VSS sg13g2_a21oi_1
X_1624_ _0263_ main_fsm_top_inst.Register_File_inst.r_addr\[2\]
+ _0262_ VDD VSS sg13g2_nor2b_1
X_1625_ _0264_ main_fsm_top_inst.Register_File_inst.r_addr\[1\]
+ main_fsm_top_inst.Register_File_inst.r_addr\[0\] VDD VSS sg13g2_nor2b_1
X_1626_ _0265_ _0263_ _0264_ VDD VSS sg13g2_and2_1
Xplace503 net502 serializer_inst.freeze_delay VDD VSS sg13g2_buf_1
X_1628_ _0084_ _0241_ _0256_ _0265_ VDD VSS sg13g2_mux2_1
X_1629_ _0267_ net547 main_fsm_top_inst.Register_File_inst.registers\[1\]\[5\]
+ VDD VSS sg13g2_nor2b_1
X_1630_ _0268_ main_fsm_top_inst.spi_top_inst.spi_reg.bit_cell5.VALUE_OUT
+ net508 VDD VSS sg13g2_and2_1
X_1631_ _0269_ main_fsm_top_inst.spi_rx.data_rg\[5\] _0244_
+ _0268_ VDD VSS sg13g2_a21oi_1
X_1632_ _0270_ afe_controller_inst.fifo.mem\[0\]\[5\] afe_controller_inst.fifo.mem\[1\]\[5\]
+ afe_controller_inst.fifo.mem\[2\]\[5\] afe_controller_inst.fifo.mem\[3\]\[5\]
+ _0007_ _0008_ VDD VSS sg13g2_mux4_1
X_1633_ _0271_ net483 _0270_ VDD VSS sg13g2_nand2_1
X_1634_ _0272_ net484 _0269_ _0271_ VDD VSS sg13g2_o21ai_1
Xplace490 net489 _0935_ VDD VSS sg13g2_buf_1
X_1636_ _0085_ _0267_ _0272_ _0265_ VDD VSS sg13g2_mux2_1
Xplace501 net500 serializer_inst.freeze_delay VDD VSS sg13g2_buf_1
X_1638_ _0275_ net545 main_fsm_top_inst.Register_File_inst.registers\[1\]\[4\]
+ VDD VSS sg13g2_nor2b_1
X_1639_ _0276_ afe_controller_inst.fifo.mem\[0\]\[4\] afe_controller_inst.fifo.mem\[1\]\[4\]
+ afe_controller_inst.fifo.mem\[2\]\[4\] afe_controller_inst.fifo.mem\[3\]\[4\]
+ _0007_ _0008_ VDD VSS sg13g2_mux4_1
X_1640_ _0277_ main_fsm_top_inst.spi_top_inst.spi_reg.bit_cell4.VALUE_OUT
+ net508 VDD VSS sg13g2_nand2_1
X_1641_ _0278_ main_fsm_top_inst.spi_rx.data_rg\[4\] _0244_
+ VDD VSS sg13g2_nand2_1
X_1642_ _0279_ _0277_ _0278_ net484 VDD VSS sg13g2_a21oi_1
X_1643_ _0280_ net483 _0276_ _0279_ VDD VSS sg13g2_a21o_1
Xplace489 net488 _0532_ VDD VSS sg13g2_buf_1
X_1645_ _0086_ _0275_ _0280_ _0265_ VDD VSS sg13g2_mux2_1
X_1646_ _0282_ net550 main_fsm_top_inst.Register_File_inst.registers\[1\]\[3\]
+ VDD VSS sg13g2_nor2b_1
X_1647_ _0283_ afe_controller_inst.fifo.mem\[0\]\[3\] afe_controller_inst.fifo.mem\[1\]\[3\]
+ afe_controller_inst.fifo.mem\[2\]\[3\] afe_controller_inst.fifo.mem\[3\]\[3\]
+ _0007_ _0008_ VDD VSS sg13g2_mux4_1
X_1648_ _0284_ net483 _0283_ VDD VSS sg13g2_nand2_1
X_1649_ _0285_ main_fsm_top_inst.MAIN_TOP_OUTPUTS\[8\] main_fsm_top_inst.MAIN_TOP_OUTPUTS\[9\]
+ afe_controller_inst.CONFIG_VALUES\[4\] _1002_ VDD VSS sg13g2_nor4_1
X_1650_ _0286_ afe_controller_inst.CONFIG_VALUES\[3\] _0285_
+ VDD VSS sg13g2_nand2_1
X_1651_ _0287_ _0775_ _0791_ VDD VSS sg13g2_nor2b_1
X_1652_ _0288_ main_fsm_top_inst.spi_rx.data_rg\[3\] main_fsm_top_inst.spi_top_inst.spi_reg.bit_cell3.VALUE_OUT
+ net509 VDD VSS sg13g2_mux2_1
X_1653_ _0289_ _0287_ _0288_ VDD VSS sg13g2_nand2_1
X_1654_ _0290_ _0284_ _0286_ _0289_ VDD VSS sg13g2_nand3_1
Xplace491 net490 net491 VDD VSS sg13g2_buf_1
X_1656_ _0087_ _0282_ _0290_ _0265_ VDD VSS sg13g2_mux2_1
X_1657_ _0292_ net552 main_fsm_top_inst.Register_File_inst.registers\[1\]\[2\]
+ VDD VSS sg13g2_nor2b_1
X_1658_ _0293_ afe_controller_inst.fifo.mem\[0\]\[2\] afe_controller_inst.fifo.mem\[1\]\[2\]
+ afe_controller_inst.fifo.mem\[2\]\[2\] afe_controller_inst.fifo.mem\[3\]\[2\]
+ _0007_ _0008_ VDD VSS sg13g2_mux4_1
X_1659_ _0294_ net483 _0293_ VDD VSS sg13g2_nand2_1
X_1660_ _0295_ afe_controller_inst.CONFIG_VALUES\[2\] _0285_
+ VDD VSS sg13g2_nand2_1
X_1661_ _0296_ _1004_ _0287_ VDD VSS sg13g2_nand2_1
X_1662_ _0297_ _0294_ _0295_ _0296_ VDD VSS sg13g2_nand3_1
Xplace486 net485 _1062_ VDD VSS sg13g2_buf_1
X_1664_ _0088_ _0292_ _0297_ _0265_ VDD VSS sg13g2_mux2_1
X_1665_ _0299_ net536 main_fsm_top_inst.Register_File_inst.registers\[1\]\[1\]
+ VDD VSS sg13g2_nor2b_1
X_1666_ _0300_ afe_controller_inst.fifo.mem\[0\]\[1\] afe_controller_inst.fifo.mem\[1\]\[1\]
+ afe_controller_inst.fifo.mem\[2\]\[1\] afe_controller_inst.fifo.mem\[3\]\[1\]
+ _0007_ _0008_ VDD VSS sg13g2_mux4_1
X_1667_ _0301_ _0250_ _0300_ VDD VSS sg13g2_nand2_1
X_1668_ _0302_ main_fsm_top_inst.spi_rx.data_rg\[1\] main_fsm_top_inst.spi_top_inst.spi_reg.bit_cell1.VALUE_OUT
+ net509 VDD VSS sg13g2_mux2_1
X_1669_ _0303_ _0287_ _0302_ VDD VSS sg13g2_nand2_1
X_1670_ _0304_ afe_controller_inst.AFE_CRTL_OUTPUTS\[10\]
+ _0285_ VDD VSS sg13g2_nand2_1
X_1671_ _0305_ _0301_ _0303_ _0304_ VDD VSS sg13g2_nand3_1
Xplace485 net484 _0243_ VDD VSS sg13g2_buf_1
X_1673_ _0089_ _0299_ _0305_ _0265_ VDD VSS sg13g2_mux2_1
X_1674_ _0307_ net551 main_fsm_top_inst.Register_File_inst.registers\[1\]\[0\]
+ VDD VSS sg13g2_nor2b_1
X_1675_ _0308_ afe_controller_inst.fifo.mem\[0\]\[0\] afe_controller_inst.fifo.mem\[1\]\[0\]
+ afe_controller_inst.fifo.mem\[2\]\[0\] afe_controller_inst.fifo.mem\[3\]\[0\]
+ _0007_ _0008_ VDD VSS sg13g2_mux4_1
X_1676_ _0309_ _0250_ _0308_ VDD VSS sg13g2_nand2_1
X_1677_ _0310_ main_fsm_top_inst.spi_rx.data_rg\[0\] main_fsm_top_inst.spi_top_inst.spi_reg.bit_cell0.VALUE_OUT
+ net508 VDD VSS sg13g2_mux2_1
X_1678_ _0311_ _0287_ _0310_ VDD VSS sg13g2_nand2_1
X_1679_ _0312_ _0309_ _0311_ VDD VSS sg13g2_nand2_1
X_1680_ _0090_ _0307_ _0312_ _0265_ VDD VSS sg13g2_mux2_1
X_1681_ _0313_ net548 main_fsm_top_inst.Register_File_inst.registers\[2\]\[6\]
+ VDD VSS sg13g2_nor2b_1
X_1682_ _0314_ main_fsm_top_inst.Register_File_inst.r_addr\[0\]
+ main_fsm_top_inst.Register_File_inst.r_addr\[1\] VDD VSS sg13g2_nor2b_1
X_1683_ _0315_ _0263_ _0314_ VDD VSS sg13g2_and2_1
Xplace494 net493 _0868_ VDD VSS sg13g2_buf_1
X_1685_ _0091_ _0313_ _0256_ _0315_ VDD VSS sg13g2_mux2_1
X_1686_ _0317_ net547 main_fsm_top_inst.Register_File_inst.registers\[2\]\[5\]
+ VDD VSS sg13g2_nor2b_1
X_1687_ _0092_ _0317_ _0272_ _0315_ VDD VSS sg13g2_mux2_1
X_1688_ _0318_ net545 main_fsm_top_inst.Register_File_inst.registers\[2\]\[4\]
+ VDD VSS sg13g2_nor2b_1
X_1689_ _0093_ _0318_ _0280_ _0315_ VDD VSS sg13g2_mux2_1
X_1690_ _0319_ net550 main_fsm_top_inst.Register_File_inst.registers\[2\]\[3\]
+ VDD VSS sg13g2_nor2b_1
X_1691_ _0094_ _0319_ _0290_ _0315_ VDD VSS sg13g2_mux2_1
X_1692_ _0320_ net552 main_fsm_top_inst.Register_File_inst.registers\[2\]\[2\]
+ VDD VSS sg13g2_nor2b_1
X_1693_ _0095_ _0320_ _0297_ _0315_ VDD VSS sg13g2_mux2_1
Xplace488 net487 _0535_ VDD VSS sg13g2_buf_1
X_1695_ _0322_ net536 main_fsm_top_inst.Register_File_inst.registers\[2\]\[1\]
+ VDD VSS sg13g2_nor2b_1
X_1696_ _0096_ _0322_ _0305_ _0315_ VDD VSS sg13g2_mux2_1
X_1697_ _0323_ net548 main_fsm_top_inst.Register_File_inst.registers\[2\]\[0\]
+ VDD VSS sg13g2_nor2b_1
X_1698_ _0097_ _0323_ _0312_ _0315_ VDD VSS sg13g2_mux2_1
X_1699_ _0324_ net548 main_fsm_top_inst.Register_File_inst.registers\[3\]\[6\]
+ VDD VSS sg13g2_nor2b_1
X_1700_ _0325_ _1012_ _0263_ VDD VSS sg13g2_and2_1
Xplace484 net483 _0250_ VDD VSS sg13g2_buf_1
X_1702_ _0098_ _0324_ _0256_ _0325_ VDD VSS sg13g2_mux2_1
X_1703_ _0327_ net547 main_fsm_top_inst.Register_File_inst.registers\[3\]\[5\]
+ VDD VSS sg13g2_nor2b_1
X_1704_ _0099_ _0327_ _0272_ _0325_ VDD VSS sg13g2_mux2_1
X_1705_ _0328_ net551 main_fsm_top_inst.Register_File_inst.registers\[3\]\[4\]
+ VDD VSS sg13g2_nor2b_1
X_1706_ _0100_ _0328_ _0280_ _0325_ VDD VSS sg13g2_mux2_1
X_1707_ _0329_ net550 main_fsm_top_inst.Register_File_inst.registers\[3\]\[3\]
+ VDD VSS sg13g2_nor2b_1
X_1708_ _0101_ _0329_ _0290_ _0325_ VDD VSS sg13g2_mux2_1
X_1709_ _0330_ net547 main_fsm_top_inst.Register_File_inst.registers\[3\]\[2\]
+ VDD VSS sg13g2_nor2b_1
X_1710_ _0102_ _0330_ _0297_ _0325_ VDD VSS sg13g2_mux2_1
X_1711_ _0331_ net536 main_fsm_top_inst.Register_File_inst.registers\[3\]\[1\]
+ VDD VSS sg13g2_nor2b_1
X_1712_ _0103_ _0331_ _0305_ _0325_ VDD VSS sg13g2_mux2_1
X_1713_ _0332_ net548 main_fsm_top_inst.Register_File_inst.registers\[3\]\[0\]
+ VDD VSS sg13g2_nor2b_1
X_1714_ _0104_ _0332_ _0312_ _0325_ VDD VSS sg13g2_mux2_1
X_1715_ _0333_ net548 main_fsm_top_inst.Register_File_inst.registers\[4\]\[6\]
+ VDD VSS sg13g2_nor2b_1
X_1716_ _0334_ main_fsm_top_inst.Register_File_inst.r_addr\[2\]
+ _0262_ VDD VSS sg13g2_and2_1
Xplace487 net486 _1062_ VDD VSS sg13g2_buf_1
X_1718_ _0336_ main_fsm_top_inst.Register_File_inst.r_addr\[0\]
+ main_fsm_top_inst.Register_File_inst.r_addr\[1\] VDD VSS sg13g2_nor2_1
X_1719_ _0337_ _0334_ _0336_ VDD VSS sg13g2_nand2_1
Xplace483 net482 _0933_ VDD VSS sg13g2_buf_1
X_1721_ _0105_ _0256_ _0333_ _0337_ VDD VSS sg13g2_mux2_1
X_1722_ _0339_ net547 main_fsm_top_inst.Register_File_inst.registers\[4\]\[5\]
+ VDD VSS sg13g2_nor2b_1
X_1723_ _0106_ _0272_ _0339_ _0337_ VDD VSS sg13g2_mux2_1
X_1724_ _0340_ net545 main_fsm_top_inst.Register_File_inst.registers\[4\]\[4\]
+ VDD VSS sg13g2_nor2b_1
X_1725_ _0107_ _0280_ _0340_ _0337_ VDD VSS sg13g2_mux2_1
X_1726_ _0341_ net550 main_fsm_top_inst.Register_File_inst.registers\[4\]\[3\]
+ VDD VSS sg13g2_nor2b_1
X_1727_ _0108_ _0290_ _0341_ _0337_ VDD VSS sg13g2_mux2_1
Xplace481 net480 _0369_ VDD VSS sg13g2_buf_1
X_1729_ _0343_ net546 main_fsm_top_inst.Register_File_inst.registers\[4\]\[2\]
+ VDD VSS sg13g2_nor2b_1
X_1730_ _0109_ _0297_ _0343_ _0337_ VDD VSS sg13g2_mux2_1
X_1731_ _0344_ net536 main_fsm_top_inst.Register_File_inst.registers\[4\]\[1\]
+ VDD VSS sg13g2_nor2b_1
X_1732_ _0110_ _0305_ _0344_ _0337_ VDD VSS sg13g2_mux2_1
X_1733_ _0345_ net546 main_fsm_top_inst.Register_File_inst.registers\[4\]\[0\]
+ VDD VSS sg13g2_nor2b_1
X_1734_ _0111_ _0312_ _0345_ _0337_ VDD VSS sg13g2_mux2_1
X_1735_ _0112_ net561 _0785_ _1061_ VDD VSS sg13g2_or3_1
X_1736_ _0346_ net549 main_fsm_top_inst.Register_File_inst.registers\[5\]\[6\]
+ VDD VSS sg13g2_nor2b_1
X_1737_ _0347_ _0264_ _0334_ VDD VSS sg13g2_nand2_1
Xplace480 net479 _0661_ VDD VSS sg13g2_buf_1
X_1739_ _0113_ _0256_ _0346_ _0347_ VDD VSS sg13g2_mux2_1
X_1740_ _0349_ net547 main_fsm_top_inst.Register_File_inst.registers\[5\]\[5\]
+ VDD VSS sg13g2_nor2b_1
X_1741_ _0114_ _0272_ _0349_ _0347_ VDD VSS sg13g2_mux2_1
X_1742_ _0350_ net534 main_fsm_top_inst.Register_File_inst.registers\[5\]\[4\]
+ VDD VSS sg13g2_nor2b_1
X_1743_ _0115_ _0280_ _0350_ _0347_ VDD VSS sg13g2_mux2_1
X_1744_ _0351_ net550 main_fsm_top_inst.Register_File_inst.registers\[5\]\[3\]
+ VDD VSS sg13g2_nor2b_1
X_1745_ _0116_ _0290_ _0351_ _0347_ VDD VSS sg13g2_mux2_1
X_1746_ _0352_ net546 main_fsm_top_inst.Register_File_inst.registers\[5\]\[2\]
+ VDD VSS sg13g2_nor2b_1
X_1747_ _0117_ _0297_ _0352_ _0347_ VDD VSS sg13g2_mux2_1
X_1748_ _0353_ net536 main_fsm_top_inst.Register_File_inst.registers\[5\]\[1\]
+ VDD VSS sg13g2_nor2b_1
X_1749_ _0118_ _0305_ _0353_ _0347_ VDD VSS sg13g2_mux2_1
X_1750_ _0354_ net535 main_fsm_top_inst.Register_File_inst.registers\[5\]\[0\]
+ VDD VSS sg13g2_nor2b_1
X_1751_ _0119_ _0312_ _0354_ _0347_ VDD VSS sg13g2_mux2_1
X_1752_ _0120_ net532 _0822_ _0866_ VDD VSS sg13g2_nand3_1
X_1753_ _0355_ main_fsm_top_inst.spi_top_inst.spi_reg.bit_cell1.VALUE_OUT
+ net493 VDD VSS sg13g2_nand2_1
X_1754_ _0356_ main_fsm_top_inst.spi_top_inst.spi_reg.bit_cell1.DATA_OUT
+ net496 VDD VSS sg13g2_nand2_1
X_1755_ _0121_ _0355_ _0356_ net540 VDD VSS sg13g2_a21oi_1
Xplace479 net478 _0679_ VDD VSS sg13g2_buf_1
X_1757_ _0358_ net548 main_fsm_top_inst.Register_File_inst.registers\[6\]\[6\]
+ VDD VSS sg13g2_nor2b_1
X_1758_ _0359_ _0314_ _0334_ VDD VSS sg13g2_nand2_1
Xplace478 net477 _0693_ VDD VSS sg13g2_buf_1
X_1760_ _0122_ _0256_ _0358_ _0359_ VDD VSS sg13g2_mux2_1
X_1761_ _0361_ net547 main_fsm_top_inst.Register_File_inst.registers\[6\]\[5\]
+ VDD VSS sg13g2_nor2b_1
X_1762_ _0123_ _0272_ _0361_ _0359_ VDD VSS sg13g2_mux2_1
X_1763_ _0362_ net545 main_fsm_top_inst.Register_File_inst.registers\[6\]\[4\]
+ VDD VSS sg13g2_nor2b_1
X_1764_ _0124_ _0280_ _0362_ _0359_ VDD VSS sg13g2_mux2_1
X_1765_ _0363_ net550 main_fsm_top_inst.Register_File_inst.registers\[6\]\[3\]
+ VDD VSS sg13g2_nor2b_1
X_1766_ _0125_ _0290_ _0363_ _0359_ VDD VSS sg13g2_mux2_1
X_1767_ _0364_ _0761_ _0667_ _0762_ VDD VSS sg13g2_a21oi_1
X_1768_ _0365_ _0364_ _0250_ afe_controller_inst.clear VDD
+ VSS sg13g2_a21oi_1
X_1769_ _0366_ net533 _0365_ VDD VSS sg13g2_nor2_1
X_1770_ _0367_ afe_controller_inst.fifo.r_ptr\[0\] afe_controller_inst.fifo.r_ptr\[1\]
+ _0366_ VDD VSS sg13g2_nand3_1
X_1771_ _0368_ afe_controller_inst.fifo.r_ptr\[2\] _0367_
+ VDD VSS sg13g2_xnor2_1
X_1772_ _0126_ net489 _0368_ VDD VSS sg13g2_and2_1
X_1773_ _0369_ _0822_ _0867_ VDD VSS sg13g2_nand2_1
Xplace502 net501 net502 VDD VSS sg13g2_buf_1
Xplace500 net499 serializer_inst.freeze_delay VDD VSS sg13g2_buf_1
Xplace477 net476 _0974_ VDD VSS sg13g2_buf_1
Xplace482 net481 _0369_ VDD VSS sg13g2_buf_1
Xplace476 net475 _0990_ VDD VSS sg13g2_buf_1
X_1779_ _0375_ main_fsm_top_inst.Register_File_inst.registers\[0\]\[7\]
+ main_fsm_top_inst.Register_File_inst.registers\[1\]\[7\] main_fsm_top_inst.Register_File_inst.registers\[2\]\[7\]
+ main_fsm_top_inst.Register_File_inst.registers\[3\]\[7\] net531
+ _0010_ VDD VSS sg13g2_mux4_1
Xplace474 net473 net474 VDD VSS sg13g2_buf_1
Xoutput248 SCAN_VALID net247 VDD VSS sg13g2_buf_1
X_1782_ _0378_ main_fsm_top_inst.Register_File_inst.registers\[4\]\[7\]
+ main_fsm_top_inst.Register_File_inst.registers\[5\]\[7\] main_fsm_top_inst.Register_File_inst.registers\[6\]\[7\]
+ main_fsm_top_inst.Register_File_inst.registers\[7\]\[7\] net531
+ net528 VDD VSS sg13g2_mux4_1
Xoutput247 SCAN_OUT net246 VDD VSS sg13g2_buf_1
X_1784_ _0380_ _0375_ _0378_ _0011_ VDD VSS sg13g2_mux2_1
X_1785_ _0381_ net505 main_fsm_top_inst.spi_tx.data_rg\[7\]
+ VDD VSS sg13g2_nor2b_1
X_1786_ _0382_ net505 _0380_ _0381_ VDD VSS sg13g2_a21oi_1
X_1787_ _0383_ net480 _0382_ VDD VSS sg13g2_nor2_1
X_1788_ _0384_ main_fsm_top_inst.spi_top_inst.load_in\[7\]
+ _0369_ _0383_ VDD VSS sg13g2_a21oi_1
X_1789_ _0127_ net541 _0384_ VDD VSS sg13g2_nor2_1
X_1790_ _0128_ net543 main_fsm_top_inst.spi_top_inst.sck_sync
+ VDD VSS sg13g2_nor2b_1
X_1791_ _0385_ net552 main_fsm_top_inst.Register_File_inst.registers\[6\]\[2\]
+ VDD VSS sg13g2_nor2b_1
X_1792_ _0129_ _0297_ _0385_ _0359_ VDD VSS sg13g2_mux2_1
X_1793_ _0130_ net543 main_fsm_top_inst.spi_top_inst.mosi_meta
+ VDD VSS sg13g2_nor2b_1
X_1794_ _0131_ net543 main_fsm_top_inst.spi_top_inst.cs_meta
+ VDD VSS sg13g2_nor2b_1
X_1795_ _0386_ net536 main_fsm_top_inst.Register_File_inst.registers\[6\]\[1\]
+ VDD VSS sg13g2_nor2b_1
X_1796_ _0132_ _0305_ _0386_ _0359_ VDD VSS sg13g2_mux2_1
X_1797_ _0387_ net535 main_fsm_top_inst.Register_File_inst.registers\[6\]\[0\]
+ VDD VSS sg13g2_nor2b_1
X_1798_ _0133_ _0312_ _0387_ _0359_ VDD VSS sg13g2_mux2_1
X_1799_ _0388_ net548 main_fsm_top_inst.Register_File_inst.registers\[7\]\[6\]
+ VDD VSS sg13g2_nor2b_1
X_1800_ _0389_ _1012_ _0334_ VDD VSS sg13g2_nand2_1
Xoutput246 MISO net245 VDD VSS sg13g2_buf_1
X_1802_ _0134_ _0256_ _0388_ _0389_ VDD VSS sg13g2_mux2_1
X_1803_ _0391_ net547 main_fsm_top_inst.Register_File_inst.registers\[7\]\[5\]
+ VDD VSS sg13g2_nor2b_1
X_1804_ _0135_ _0272_ _0391_ _0389_ VDD VSS sg13g2_mux2_1
X_1805_ _0392_ net545 main_fsm_top_inst.Register_File_inst.registers\[7\]\[4\]
+ VDD VSS sg13g2_nor2b_1
X_1806_ _0136_ _0280_ _0392_ _0389_ VDD VSS sg13g2_mux2_1
X_1807_ _0393_ net550 main_fsm_top_inst.Register_File_inst.registers\[7\]\[3\]
+ VDD VSS sg13g2_nor2b_1
X_1808_ _0137_ _0290_ _0393_ _0389_ VDD VSS sg13g2_mux2_1
X_1809_ _0394_ net552 main_fsm_top_inst.Register_File_inst.registers\[7\]\[2\]
+ VDD VSS sg13g2_nor2b_1
X_1810_ _0138_ _0297_ _0394_ _0389_ VDD VSS sg13g2_mux2_1
X_1811_ _0395_ net536 main_fsm_top_inst.Register_File_inst.registers\[7\]\[1\]
+ VDD VSS sg13g2_nor2b_1
X_1812_ _0139_ _0305_ _0395_ _0389_ VDD VSS sg13g2_mux2_1
X_1813_ _0140_ net544 main_fsm_top_inst.spi_top_inst.sck_meta
+ VDD VSS sg13g2_nor2b_1
X_1814_ _0396_ net546 main_fsm_top_inst.Register_File_inst.registers\[7\]\[0\]
+ VDD VSS sg13g2_nor2b_1
X_1815_ _0141_ _0312_ _0396_ _0389_ VDD VSS sg13g2_mux2_1
X_1816_ _0142_ net549 net241 VDD VSS sg13g2_nor2b_1
X_1817_ _0397_ main_fsm_top_inst.spi_tx.bypass_rg _0242_ _0247_
+ _0866_ VDD VSS sg13g2_and4_1
Xoutput245 DATA_READY net244 VDD VSS sg13g2_buf_1
X_1819_ _0399_ main_fsm_top_inst.spi_tx.data_rg\[7\] _0397_
+ VDD VSS sg13g2_nor2_1
X_1820_ _0400_ main_fsm_top_inst.spi_tx.bypass_rg _0242_ _0247_
+ _0866_ VDD VSS sg13g2_nand4_1
Xinput244 net243 SCK VDD VSS sg13g2_buf_1
X_1822_ _0402_ _0380_ _0400_ VDD VSS sg13g2_nor2_1
X_1823_ _0143_ net543 _0399_ _0402_ VDD VSS sg13g2_nor3_1
X_1824_ _0403_ adc_ready_out_sig VDD VSS sg13g2_inv_1
X_1825_ _0146_ _0931_ _0403_ _0629_ VDD VSS sg13g2_nand3_1
X_1826_ _0147_ net553 serializer_inst.fake_adc.sipo_flip_flops\[8\]
+ VDD VSS sg13g2_nor2b_1
X_1827_ _0404_ afe_controller_inst.fifo.mem\[0\]\[7\] afe_controller_inst.fifo.mem\[1\]\[7\]
+ afe_controller_inst.fifo.mem\[2\]\[7\] afe_controller_inst.fifo.mem\[3\]\[7\]
+ _0007_ _0008_ VDD VSS sg13g2_mux4_1
X_1828_ _0405_ net483 _0404_ VDD VSS sg13g2_and2_1
Xinput243 net242 RESET VDD VSS sg13g2_buf_1
X_1830_ _0407_ net535 main_fsm_top_inst.Register_File_inst.registers\[7\]\[7\]
+ VDD VSS sg13g2_nor2b_1
X_1831_ _0148_ _0405_ _0407_ _0389_ VDD VSS sg13g2_mux2_1
X_1832_ _0408_ afe_controller_inst.CONFIG_VALUES\[4\] net484
+ _0279_ VDD VSS sg13g2_a21oi_1
X_1833_ _0149_ net534 _0408_ VDD VSS sg13g2_nor2_1
X_1834_ _0409_ net535 main_fsm_top_inst.Register_File_inst.registers\[6\]\[7\]
+ VDD VSS sg13g2_nor2b_1
X_1835_ _0150_ _0405_ _0409_ _0359_ VDD VSS sg13g2_mux2_1
X_1836_ _0410_ net535 main_fsm_top_inst.Register_File_inst.registers\[5\]\[7\]
+ VDD VSS sg13g2_nor2b_1
X_1837_ _0151_ _0405_ _0410_ _0347_ VDD VSS sg13g2_mux2_1
X_1838_ _0411_ net535 main_fsm_top_inst.Register_File_inst.registers\[4\]\[7\]
+ VDD VSS sg13g2_nor2b_1
X_1839_ _0152_ _0405_ _0411_ _0337_ VDD VSS sg13g2_mux2_1
X_1840_ _0412_ net551 main_fsm_top_inst.Register_File_inst.registers\[3\]\[7\]
+ VDD VSS sg13g2_nor2b_1
X_1841_ _0153_ _0412_ _0405_ _0325_ VDD VSS sg13g2_mux2_1
X_1842_ _0413_ net551 main_fsm_top_inst.Register_File_inst.registers\[2\]\[7\]
+ VDD VSS sg13g2_nor2b_1
X_1843_ _0154_ _0413_ _0405_ _0315_ VDD VSS sg13g2_mux2_1
X_1844_ _0414_ net551 main_fsm_top_inst.Register_File_inst.registers\[1\]\[7\]
+ VDD VSS sg13g2_nor2b_1
X_1845_ _0155_ _0414_ _0405_ _0265_ VDD VSS sg13g2_mux2_1
X_1846_ _0415_ _0791_ _0788_ VDD VSS sg13g2_nand2_1
X_1847_ _0416_ net512 _0415_ _0260_ VDD VSS sg13g2_o21ai_1
X_1848_ _0417_ net564 _0416_ net511 VDD VSS sg13g2_a21oi_1
X_1849_ _0418_ net564 _0819_ VDD VSS sg13g2_and2_1
X_1850_ _0156_ _0417_ _0418_ net532 VDD VSS sg13g2_o21ai_1
X_1851_ _0157_ net242 main_fsm_top_inst.Register_File_inst.registers\[0\]\[7\]
+ VDD VSS sg13g2_or2_1
X_1852_ _0419_ afe_controller_inst.fifo.w_ptr\[0\] _0925_
+ VDD VSS sg13g2_and2_1
X_1853_ _0420_ afe_controller_inst.clear _0419_ net565 VDD
+ VSS sg13g2_o21ai_1
X_1854_ _0421_ net527 _0765_ VDD VSS sg13g2_nor2_1
X_1855_ _0422_ net527 _0420_ _0421_ _0419_ VDD VSS sg13g2_a22oi_1
X_1856_ _0160_ net556 _0422_ VDD VSS sg13g2_nor2_1
X_1857_ _0423_ afe_controller_inst.clear _0925_ net565 VDD
+ VSS sg13g2_o21ai_1
X_1858_ _0424_ afe_controller_inst.fifo.w_ptr\[0\] _0423_
+ VDD VSS sg13g2_nand2_1
X_1859_ _0161_ _0927_ _0424_ net553 VDD VSS sg13g2_a21oi_1
X_1860_ _0425_ afe_controller_inst.fifo.r_ptr\[0\] _0366_
+ VDD VSS sg13g2_nand2_1
X_1861_ _0426_ afe_controller_inst.fifo.r_ptr\[1\] _0425_
+ VDD VSS sg13g2_xnor2_1
X_1862_ _0162_ net489 _0426_ VDD VSS sg13g2_and2_1
X_1863_ _0427_ net533 _0365_ afe_controller_inst.fifo.r_ptr\[0\]
+ VDD VSS sg13g2_o21ai_1
X_1864_ _0428_ afe_controller_inst.fifo.r_ptr\[0\] _0765_
+ VDD VSS sg13g2_nor2_1
X_1865_ _0429_ _0364_ _0250_ _0428_ VDD VSS sg13g2_nand3_1
X_1866_ _0163_ _0427_ _0429_ net556 VDD VSS sg13g2_a21oi_1
X_1867_ _0430_ main_fsm_top_inst.Register_File_inst.registers\[0\]\[6\]
+ main_fsm_top_inst.Register_File_inst.registers\[1\]\[6\] main_fsm_top_inst.Register_File_inst.registers\[2\]\[6\]
+ main_fsm_top_inst.Register_File_inst.registers\[3\]\[6\] net530
+ _0010_ VDD VSS sg13g2_mux4_1
X_1868_ _0431_ main_fsm_top_inst.Register_File_inst.registers\[4\]\[6\]
+ main_fsm_top_inst.Register_File_inst.registers\[5\]\[6\] main_fsm_top_inst.Register_File_inst.registers\[6\]\[6\]
+ main_fsm_top_inst.Register_File_inst.registers\[7\]\[6\] net530
+ _0010_ VDD VSS sg13g2_mux4_1
X_1869_ _0432_ _0430_ _0431_ _0011_ VDD VSS sg13g2_mux2_1
X_1870_ _0433_ net505 main_fsm_top_inst.spi_tx.data_rg\[6\]
+ VDD VSS sg13g2_nor2b_1
X_1871_ _0434_ net505 _0432_ _0433_ VDD VSS sg13g2_a21oi_1
X_1872_ _0435_ _0369_ _0434_ VDD VSS sg13g2_nor2_1
X_1873_ _0436_ main_fsm_top_inst.spi_top_inst.load_in\[6\]
+ net481 _0435_ VDD VSS sg13g2_a21oi_1
X_1874_ _0164_ net537 _0436_ VDD VSS sg13g2_nor2_1
X_1875_ _0437_ main_fsm_top_inst.Register_File_inst.registers\[0\]\[5\]
+ main_fsm_top_inst.Register_File_inst.registers\[1\]\[5\] main_fsm_top_inst.Register_File_inst.registers\[2\]\[5\]
+ main_fsm_top_inst.Register_File_inst.registers\[3\]\[5\] net530
+ net529 VDD VSS sg13g2_mux4_1
X_1876_ _0438_ main_fsm_top_inst.Register_File_inst.registers\[4\]\[5\]
+ main_fsm_top_inst.Register_File_inst.registers\[5\]\[5\] main_fsm_top_inst.Register_File_inst.registers\[6\]\[5\]
+ main_fsm_top_inst.Register_File_inst.registers\[7\]\[5\] net530
+ net529 VDD VSS sg13g2_mux4_1
X_1877_ _0439_ _0437_ _0438_ _0011_ VDD VSS sg13g2_mux2_1
X_1878_ _0440_ net506 main_fsm_top_inst.spi_tx.data_rg\[5\]
+ VDD VSS sg13g2_nor2b_1
X_1879_ _0441_ net506 _0439_ _0440_ VDD VSS sg13g2_a21oi_1
X_1880_ _0442_ _0369_ _0441_ VDD VSS sg13g2_nor2_1
X_1881_ _0443_ main_fsm_top_inst.spi_top_inst.load_in\[5\]
+ net481 _0442_ VDD VSS sg13g2_a21oi_1
X_1882_ _0165_ net537 _0443_ VDD VSS sg13g2_nor2_1
X_1883_ _0444_ main_fsm_top_inst.Register_File_inst.registers\[0\]\[4\]
+ main_fsm_top_inst.Register_File_inst.registers\[1\]\[4\] main_fsm_top_inst.Register_File_inst.registers\[2\]\[4\]
+ main_fsm_top_inst.Register_File_inst.registers\[3\]\[4\] net531
+ net528 VDD VSS sg13g2_mux4_1
X_1884_ _0445_ main_fsm_top_inst.Register_File_inst.registers\[4\]\[4\]
+ main_fsm_top_inst.Register_File_inst.registers\[5\]\[4\] main_fsm_top_inst.Register_File_inst.registers\[6\]\[4\]
+ main_fsm_top_inst.Register_File_inst.registers\[7\]\[4\] net531
+ net528 VDD VSS sg13g2_mux4_1
X_1885_ _0446_ _0444_ _0445_ _0011_ VDD VSS sg13g2_mux2_1
X_1886_ _0447_ net505 main_fsm_top_inst.spi_tx.data_rg\[4\]
+ VDD VSS sg13g2_nor2b_1
X_1887_ _0448_ net505 _0446_ _0447_ VDD VSS sg13g2_a21oi_1
X_1888_ _0449_ net480 _0448_ VDD VSS sg13g2_nor2_1
X_1889_ _0450_ main_fsm_top_inst.spi_top_inst.load_in\[4\]
+ _0369_ _0449_ VDD VSS sg13g2_a21oi_1
X_1890_ _0166_ net542 _0450_ VDD VSS sg13g2_nor2_1
X_1891_ _0451_ main_fsm_top_inst.Register_File_inst.registers\[0\]\[3\]
+ main_fsm_top_inst.Register_File_inst.registers\[1\]\[3\] main_fsm_top_inst.Register_File_inst.registers\[2\]\[3\]
+ main_fsm_top_inst.Register_File_inst.registers\[3\]\[3\] net530
+ net528 VDD VSS sg13g2_mux4_1
X_1892_ _0452_ main_fsm_top_inst.Register_File_inst.registers\[4\]\[3\]
+ main_fsm_top_inst.Register_File_inst.registers\[5\]\[3\] main_fsm_top_inst.Register_File_inst.registers\[6\]\[3\]
+ main_fsm_top_inst.Register_File_inst.registers\[7\]\[3\] net530
+ net528 VDD VSS sg13g2_mux4_1
X_1893_ _0453_ _0451_ _0452_ _0011_ VDD VSS sg13g2_mux2_1
X_1894_ _0454_ net506 main_fsm_top_inst.spi_tx.data_rg\[3\]
+ VDD VSS sg13g2_nor2b_1
X_1895_ _0455_ net506 _0453_ _0454_ VDD VSS sg13g2_a21oi_1
X_1896_ _0456_ net481 _0455_ VDD VSS sg13g2_nor2_1
X_1897_ _0457_ main_fsm_top_inst.spi_top_inst.load_in\[3\]
+ net481 _0456_ VDD VSS sg13g2_a21oi_1
X_1898_ _0167_ net537 _0457_ VDD VSS sg13g2_nor2_1
X_1899_ _0458_ main_fsm_top_inst.Register_File_inst.registers\[0\]\[2\]
+ main_fsm_top_inst.Register_File_inst.registers\[1\]\[2\] main_fsm_top_inst.Register_File_inst.registers\[2\]\[2\]
+ main_fsm_top_inst.Register_File_inst.registers\[3\]\[2\] net531
+ net529 VDD VSS sg13g2_mux4_1
X_1900_ _0459_ main_fsm_top_inst.Register_File_inst.registers\[4\]\[2\]
+ main_fsm_top_inst.Register_File_inst.registers\[5\]\[2\] main_fsm_top_inst.Register_File_inst.registers\[6\]\[2\]
+ main_fsm_top_inst.Register_File_inst.registers\[7\]\[2\] net531
+ net529 VDD VSS sg13g2_mux4_1
X_1901_ _0460_ _0458_ _0459_ _0011_ VDD VSS sg13g2_mux2_1
X_1902_ _0461_ net506 main_fsm_top_inst.spi_tx.data_rg\[2\]
+ VDD VSS sg13g2_nor2b_1
X_1903_ _0462_ net506 _0460_ _0461_ VDD VSS sg13g2_a21oi_1
X_1904_ _0463_ net480 _0462_ VDD VSS sg13g2_nor2_1
X_1905_ _0464_ main_fsm_top_inst.spi_top_inst.load_in\[2\]
+ net481 _0463_ VDD VSS sg13g2_a21oi_1
X_1906_ _0168_ net537 _0464_ VDD VSS sg13g2_nor2_1
X_1907_ _0465_ main_fsm_top_inst.Register_File_inst.registers\[0\]\[1\]
+ main_fsm_top_inst.Register_File_inst.registers\[1\]\[1\] main_fsm_top_inst.Register_File_inst.registers\[2\]\[1\]
+ main_fsm_top_inst.Register_File_inst.registers\[3\]\[1\] net530
+ net528 VDD VSS sg13g2_mux4_1
X_1908_ _0466_ main_fsm_top_inst.Register_File_inst.registers\[4\]\[1\]
+ main_fsm_top_inst.Register_File_inst.registers\[5\]\[1\] main_fsm_top_inst.Register_File_inst.registers\[6\]\[1\]
+ main_fsm_top_inst.Register_File_inst.registers\[7\]\[1\] net530
+ net528 VDD VSS sg13g2_mux4_1
X_1909_ _0467_ _0465_ _0466_ _0011_ VDD VSS sg13g2_mux2_1
X_1910_ _0468_ net506 main_fsm_top_inst.spi_tx.data_rg\[1\]
+ VDD VSS sg13g2_nor2b_1
X_1911_ _0469_ net506 _0467_ _0468_ VDD VSS sg13g2_a21oi_1
X_1912_ _0470_ net481 _0469_ VDD VSS sg13g2_nor2_1
X_1913_ _0471_ main_fsm_top_inst.spi_top_inst.load_in\[1\]
+ net481 _0470_ VDD VSS sg13g2_a21oi_1
X_1914_ _0169_ net537 _0471_ VDD VSS sg13g2_nor2_1
X_1915_ _0472_ main_fsm_top_inst.Register_File_inst.registers\[0\]\[0\]
+ main_fsm_top_inst.Register_File_inst.registers\[1\]\[0\] main_fsm_top_inst.Register_File_inst.registers\[2\]\[0\]
+ main_fsm_top_inst.Register_File_inst.registers\[3\]\[0\] net531
+ net529 VDD VSS sg13g2_mux4_1
X_1916_ _0473_ main_fsm_top_inst.Register_File_inst.registers\[4\]\[0\]
+ main_fsm_top_inst.Register_File_inst.registers\[5\]\[0\] main_fsm_top_inst.Register_File_inst.registers\[6\]\[0\]
+ main_fsm_top_inst.Register_File_inst.registers\[7\]\[0\] net531
+ net529 VDD VSS sg13g2_mux4_1
X_1917_ _0474_ _0472_ _0473_ _0011_ VDD VSS sg13g2_mux2_1
X_1918_ _0475_ main_fsm_top_inst.spi_tx.bypass_rg main_fsm_top_inst.spi_tx.data_rg\[0\]
+ VDD VSS sg13g2_nor2b_1
X_1919_ _0476_ net505 _0474_ _0475_ VDD VSS sg13g2_a21oi_1
X_1920_ _0477_ net480 _0476_ VDD VSS sg13g2_nor2_1
X_1921_ _0478_ main_fsm_top_inst.spi_top_inst.load_in\[0\]
+ net480 _0477_ VDD VSS sg13g2_a21oi_1
X_1922_ _0170_ net537 _0478_ VDD VSS sg13g2_nor2_1
X_1923_ _0479_ _0824_ _0831_ VDD VSS sg13g2_nand2_1
X_1924_ _0480_ net507 _0479_ net567 VDD VSS sg13g2_o21ai_1
Xinput242 net241 MOSI VDD VSS sg13g2_buf_1
X_1926_ _0482_ main_fsm_top_inst.spi_top_inst.counter_module.COUNTER\[0\]
+ main_fsm_top_inst.spi_top_inst.counter_module.COUNTER\[1\]
+ net507 VDD VSS sg13g2_a21oi_1
X_1927_ _0483_ _0480_ _0482_ main_fsm_top_inst.spi_top_inst.counter_module.COUNTER\[2\]
+ VDD VSS sg13g2_o21ai_1
X_1928_ _0484_ main_fsm_top_inst.spi_top_inst.counter_module.COUNTER\[0\]
+ main_fsm_top_inst.spi_top_inst.counter_module.COUNTER\[1\]
+ VDD VSS sg13g2_nand2_1
X_1929_ _0485_ main_fsm_top_inst.spi_top_inst.counter_module.COUNTER\[2\]
+ net507 _0484_ _0480_ VDD VSS sg13g2_or4_1
X_1930_ _0171_ _0483_ _0485_ net557 VDD VSS sg13g2_a21oi_1
X_1931_ _0172_ net541 net239 VDD VSS sg13g2_nor2b_1
X_1932_ _0486_ main_fsm_top_inst.spi_top_inst.counter_module.COUNTER\[0\]
+ VDD VSS sg13g2_inv_1
X_1933_ _0487_ _0486_ _0480_ VDD VSS sg13g2_nor2_1
X_1934_ _0488_ main_fsm_top_inst.spi_top_inst.counter_module.COUNTER\[1\]
+ _0487_ VDD VSS sg13g2_xor2_1
X_1935_ _0173_ net532 _0643_ _0488_ VDD VSS sg13g2_and3_1
X_1936_ _0489_ main_fsm_top_inst.spi_top_inst.counter_module.COUNTER\[0\]
+ net507 _0480_ VDD VSS sg13g2_nor3_1
X_1937_ _0490_ main_fsm_top_inst.spi_top_inst.counter_module.COUNTER\[0\]
+ _0480_ _0489_ VDD VSS sg13g2_a21oi_1
X_1938_ _0174_ net557 _0490_ VDD VSS sg13g2_nor2_1
X_1939_ _0491_ afe_controller_inst.AFE_CRTL_OUTPUTS\[10\]
+ net484 VDD VSS sg13g2_nand2_1
X_1940_ _0175_ _0303_ _0491_ net534 VDD VSS sg13g2_a21oi_1
X_1941_ _0492_ afe_controller_inst.CONFIG_VALUES\[3\] net484
+ VDD VSS sg13g2_nand2_1
X_1942_ _0176_ _0289_ _0492_ net534 VDD VSS sg13g2_a21oi_1
X_1943_ _0493_ _0285_ afe_controller_inst.CONFIG_VALUES\[0\]
+ net484 VDD VSS sg13g2_nand3b_1
X_1944_ _0177_ _0311_ _0493_ net534 VDD VSS sg13g2_a21oi_1
X_1945_ _0494_ afe_controller_inst.CONFIG_VALUES\[2\] net484
+ VDD VSS sg13g2_nand2_1
X_1946_ _0178_ _0296_ _0494_ net534 VDD VSS sg13g2_a21oi_1
X_1947_ _0495_ net527 _0419_ afe_controller_inst.clear VDD
+ VSS sg13g2_a21oi_1
X_1948_ _0496_ net533 _0495_ afe_controller_inst.fifo.w_ptr\[2\]
+ VDD VSS sg13g2_o21ai_1
X_1949_ _0497_ afe_controller_inst.fifo.w_ptr\[2\] _0930_
+ _0765_ _0970_ VDD VSS sg13g2_or4_1
Xinput241 net240 FREEZE VDD VSS sg13g2_buf_1
X_1951_ _0179_ _0496_ _0497_ net556 VDD VSS sg13g2_a21oi_1
X_1952_ _0499_ _1007_ _0264_ VDD VSS sg13g2_nor2b_1
X_1953_ _0500_ _1003_ _0302_ _0499_ VDD VSS sg13g2_a21o_1
X_1954_ _0501_ net510 _1007_ _1000_ VDD VSS sg13g2_o21ai_1
X_1955_ _0502_ _1000_ _0500_ _0501_ main_fsm_top_inst.Register_File_inst.r_addr\[1\]
+ VDD VSS sg13g2_a22oi_1
X_1956_ _0180_ net534 _0502_ VDD VSS sg13g2_nor2_1
X_1957_ _0503_ _1000_ VDD VSS sg13g2_inv_1
X_1958_ _0504_ _1003_ _0310_ VDD VSS sg13g2_nand2_1
X_1959_ _0505_ net510 _1003_ _0504_ VDD VSS sg13g2_o21ai_1
X_1960_ _0506_ net510 _0503_ _0505_ VDD VSS sg13g2_a21oi_1
X_1961_ _0507_ net510 _1000_ net532 VDD VSS sg13g2_o21ai_1
X_1962_ _0181_ _1006_ _0506_ _0507_ VDD VSS sg13g2_a21oi_1
X_1963_ _0508_ main_fsm_top_inst.spi_tx.data_rg\[6\] _0397_
+ VDD VSS sg13g2_nor2_1
X_1964_ _0509_ _0400_ _0432_ VDD VSS sg13g2_nor2_1
X_1965_ _0182_ net541 _0508_ _0509_ VDD VSS sg13g2_nor3_1
X_1966_ _0510_ main_fsm_top_inst.spi_tx.data_rg\[5\] _0397_
+ VDD VSS sg13g2_nor2_1
X_1967_ _0511_ _0400_ _0439_ VDD VSS sg13g2_nor2_1
X_1968_ _0183_ net541 _0510_ _0511_ VDD VSS sg13g2_nor3_1
X_1969_ _0512_ main_fsm_top_inst.spi_tx.data_rg\[4\] _0397_
+ VDD VSS sg13g2_nor2_1
X_1970_ _0513_ _0400_ _0446_ VDD VSS sg13g2_nor2_1
X_1971_ _0184_ net543 _0512_ _0513_ VDD VSS sg13g2_nor3_1
X_1972_ _0514_ main_fsm_top_inst.spi_tx.data_rg\[3\] _0397_
+ VDD VSS sg13g2_nor2_1
X_1973_ _0515_ _0400_ _0453_ VDD VSS sg13g2_nor2_1
X_1974_ _0185_ net541 _0514_ _0515_ VDD VSS sg13g2_nor3_1
X_1975_ _0516_ main_fsm_top_inst.spi_tx.data_rg\[2\] _0397_
+ VDD VSS sg13g2_nor2_1
X_1976_ _0517_ _0400_ _0460_ VDD VSS sg13g2_nor2_1
X_1977_ _0186_ net543 _0516_ _0517_ VDD VSS sg13g2_nor3_1
X_1978_ _0518_ main_fsm_top_inst.spi_tx.data_rg\[1\] _0397_
+ VDD VSS sg13g2_nor2_1
X_1979_ _0519_ _0400_ _0467_ VDD VSS sg13g2_nor2_1
X_1980_ _0187_ net541 _0518_ _0519_ VDD VSS sg13g2_nor3_1
X_1981_ _0520_ main_fsm_top_inst.spi_tx.data_rg\[0\] _0397_
+ VDD VSS sg13g2_nor2_1
X_1982_ _0521_ _0400_ _0474_ VDD VSS sg13g2_nor2_1
X_1983_ _0188_ net543 _0520_ _0521_ VDD VSS sg13g2_nor3_1
X_1984_ _0189_ _0708_ net471 net477 _0744_ VDD VSS sg13g2_nor4_1
X_1985_ _0522_ main_fsm_top_inst.spi_top_inst.spi_reg.bit_cell6.VALUE_OUT
+ _1062_ VDD VSS sg13g2_nand2_1
X_1986_ _0523_ _1062_ main_fsm_top_inst.spi_rx.data_rg\[6\]
+ VDD VSS sg13g2_nand2b_1
X_1987_ _0190_ _0522_ _0523_ net538 VDD VSS sg13g2_a21oi_1
X_1988_ _0524_ main_fsm_top_inst.spi_top_inst.spi_reg.bit_cell7.VALUE_OUT
+ net493 VDD VSS sg13g2_nand2_1
X_1989_ _0525_ main_fsm_top_inst.spi_top_inst.spi_reg.bit_cell7.DATA_OUT
+ net496 VDD VSS sg13g2_nand2_1
X_1990_ _0192_ _0524_ _0525_ net538 VDD VSS sg13g2_a21oi_1
X_1991_ _0526_ main_fsm_top_inst.spi_top_inst.spi_reg.bit_cell5.VALUE_OUT
+ net485 VDD VSS sg13g2_nand2_1
X_1992_ _0527_ net485 main_fsm_top_inst.spi_rx.data_rg\[5\]
+ VDD VSS sg13g2_nand2b_1
X_1993_ _0193_ _0526_ _0527_ net542 VDD VSS sg13g2_a21oi_1
X_1994_ _0528_ main_fsm_top_inst.spi_top_inst.spi_reg.bit_cell4.VALUE_OUT
+ net485 VDD VSS sg13g2_nand2_1
X_1995_ _0529_ net485 main_fsm_top_inst.spi_rx.data_rg\[4\]
+ VDD VSS sg13g2_nand2b_1
X_1996_ _0194_ _0528_ _0529_ net542 VDD VSS sg13g2_a21oi_1
X_1997_ _0530_ main_fsm_top_inst.spi_top_inst.spi_reg.bit_cell3.VALUE_OUT
+ net486 VDD VSS sg13g2_nand2_1
X_1998_ _0531_ net486 main_fsm_top_inst.spi_rx.data_rg\[3\]
+ VDD VSS sg13g2_nand2b_1
X_1999_ _0195_ _0530_ _0531_ net539 VDD VSS sg13g2_a21oi_1
X_2000_ _0532_ serializer_inst.fake_adc.skid.bypass_rg _0403_
+ net238 VDD VSS sg13g2_and3_1
Xinput240 net239 CS VDD VSS sg13g2_buf_1
X_2002_ _0534_ serializer_inst.fake_adc.sipo_flip_flops\[9\]
+ net488 VDD VSS sg13g2_nand2_1
X_2003_ _0535_ serializer_inst.fake_adc.skid.bypass_rg _0403_
+ net238 VDD VSS sg13g2_nand3_1
Xinput239 net238 ADC_INPUT_VALID VDD VSS sg13g2_buf_1
X_2005_ _0537_ serializer_inst.fake_adc.skid.data_rg\[9\]
+ net487 VDD VSS sg13g2_nand2_1
X_2006_ _0196_ _0534_ _0537_ net553 VDD VSS sg13g2_a21oi_1
X_2007_ _0197_ net549 net243 VDD VSS sg13g2_nor2b_1
X_2008_ _0538_ main_fsm_top_inst.spi_top_inst.spi_reg.bit_cell2.VALUE_OUT
+ net486 VDD VSS sg13g2_nand2_1
X_2009_ _0539_ net486 main_fsm_top_inst.spi_rx.data_rg\[2\]
+ VDD VSS sg13g2_nand2b_1
X_2010_ _0198_ _0538_ _0539_ net539 VDD VSS sg13g2_a21oi_1
X_2011_ _0540_ afe_controller_inst.fifo.mem\[3\]\[7\] net491
+ VDD VSS sg13g2_nand2_1
X_2012_ _0541_ serializer_inst.fake_adc.sipo_flip_flops\[7\]
+ net503 VDD VSS sg13g2_nand2_1
X_2013_ _0542_ net503 serializer_inst.fake_adc.skid.data_rg\[7\]
+ VDD VSS sg13g2_nand2b_1
X_2014_ _0543_ _0541_ _0542_ _0922_ VDD VSS sg13g2_a21oi_1
X_2015_ _0544_ net473 _0543_ VDD VSS sg13g2_nand2_1
X_2016_ _0199_ net473 _0540_ _0544_ VDD VSS sg13g2_o21ai_1
X_2017_ _0545_ _0988_ _0543_ VDD VSS sg13g2_nand2_1
X_2018_ _0546_ afe_controller_inst.fifo.mem\[2\]\[7\] net491
+ net475 VDD VSS sg13g2_nand3_1
X_2019_ _0200_ _0545_ _0546_ VDD VSS sg13g2_nand2_1
X_2020_ _0547_ _0971_ _0543_ VDD VSS sg13g2_nand2_1
X_2021_ _0548_ afe_controller_inst.fifo.mem\[1\]\[7\] net491
+ net476 VDD VSS sg13g2_nand3_1
X_2022_ _0201_ _0547_ _0548_ VDD VSS sg13g2_nand2_1
X_2023_ _0549_ _0928_ _0543_ VDD VSS sg13g2_nand2_1
X_2024_ _0550_ afe_controller_inst.fifo.mem\[0\]\[7\] net482
+ net491 VDD VSS sg13g2_nand3_1
X_2025_ _0202_ _0549_ _0550_ VDD VSS sg13g2_nand2_1
X_2026_ _0551_ main_fsm_top_inst.spi_top_inst.spi_reg.bit_cell1.VALUE_OUT
+ net486 VDD VSS sg13g2_nand2_1
X_2027_ _0552_ net486 main_fsm_top_inst.spi_rx.data_rg\[1\]
+ VDD VSS sg13g2_nand2b_1
X_2028_ _0203_ _0551_ _0552_ net539 VDD VSS sg13g2_a21oi_1
X_2029_ _0553_ main_fsm_top_inst.spi_top_inst.spi_reg.bit_cell0.VALUE_OUT
+ net485 VDD VSS sg13g2_nand2_1
X_2030_ _0554_ net485 main_fsm_top_inst.spi_rx.data_rg\[0\]
+ VDD VSS sg13g2_nand2b_1
X_2031_ _0204_ _0553_ _0554_ net542 VDD VSS sg13g2_a21oi_1
X_2032_ _0555_ serializer_inst.fake_adc.sipo_flip_flops\[8\]
+ net488 VDD VSS sg13g2_nand2_1
X_2033_ _0556_ serializer_inst.fake_adc.skid.data_rg\[8\]
+ net487 VDD VSS sg13g2_nand2_1
Xinput238 net237 ADC_INPUT VDD VSS sg13g2_buf_1
X_2035_ _0205_ _0555_ _0556_ net553 VDD VSS sg13g2_a21oi_1
X_2036_ _0558_ serializer_inst.fake_adc.sipo_flip_flops\[7\]
+ net488 VDD VSS sg13g2_nand2_1
X_2037_ _0559_ serializer_inst.fake_adc.skid.data_rg\[7\]
+ net487 VDD VSS sg13g2_nand2_1
X_2038_ _0206_ _0558_ _0559_ net554 VDD VSS sg13g2_a21oi_1
X_2039_ _0560_ serializer_inst.fake_adc.sipo_flip_flops\[6\]
+ net488 VDD VSS sg13g2_nand2_1
X_2040_ _0561_ serializer_inst.fake_adc.skid.data_rg\[6\]
+ net487 VDD VSS sg13g2_nand2_1
X_2041_ _0207_ _0560_ _0561_ net555 VDD VSS sg13g2_a21oi_1
X_2042_ _0562_ serializer_inst.fake_adc.sipo_flip_flops\[5\]
+ net488 VDD VSS sg13g2_nand2_1
X_2043_ _0563_ serializer_inst.fake_adc.skid.data_rg\[5\]
+ net487 VDD VSS sg13g2_nand2_1
X_2044_ _0208_ _0562_ _0563_ net555 VDD VSS sg13g2_a21oi_1
X_2045_ _0564_ serializer_inst.fake_adc.sipo_flip_flops\[4\]
+ net488 VDD VSS sg13g2_nand2_1
X_2046_ _0565_ serializer_inst.fake_adc.skid.data_rg\[4\]
+ net487 VDD VSS sg13g2_nand2_1
X_2047_ _0209_ _0564_ _0565_ net555 VDD VSS sg13g2_a21oi_1
X_2048_ _0566_ serializer_inst.fake_adc.sipo_flip_flops\[3\]
+ net488 VDD VSS sg13g2_nand2_1
X_2049_ _0567_ serializer_inst.fake_adc.skid.data_rg\[3\]
+ net487 VDD VSS sg13g2_nand2_1
X_2050_ _0210_ _0566_ _0567_ net554 VDD VSS sg13g2_a21oi_1
X_2051_ _0568_ main_fsm_top_inst.MAIN_TOP_OUTPUTS\[1\] main_fsm_top_inst.MAIN_TOP_OUTPUTS\[0\]
+ _0858_ _0369_ VDD VSS sg13g2_a22oi_1
X_2052_ _0569_ net533 _0568_ VDD VSS sg13g2_nor2_1
X_2053_ _0570_ _0369_ VDD VSS sg13g2_inv_1
X_2054_ _0571_ net564 _0570_ main_fsm_top_inst.MAIN_TOP_OUTPUTS\[1\]
+ VDD VSS sg13g2_a21oi_1
X_2055_ _0211_ net562 _0569_ _0571_ VDD VSS sg13g2_nor3_1
X_2056_ _0572_ serializer_inst.fake_adc.sipo_flip_flops\[2\]
+ net488 VDD VSS sg13g2_nand2_1
X_2057_ _0573_ serializer_inst.fake_adc.skid.data_rg\[2\]
+ net487 VDD VSS sg13g2_nand2_1
X_2058_ _0212_ _0572_ _0573_ net554 VDD VSS sg13g2_a21oi_1
X_2059_ _0574_ serializer_inst.fake_adc.sipo_flip_flops\[1\]
+ _0532_ VDD VSS sg13g2_nand2_1
X_2060_ _0575_ serializer_inst.fake_adc.skid.data_rg\[1\]
+ _0535_ VDD VSS sg13g2_nand2_1
X_2061_ _0213_ _0574_ _0575_ net553 VDD VSS sg13g2_a21oi_1
X_2062_ _0576_ serializer_inst.fake_adc.sipo_flip_flops\[0\]
+ _0532_ VDD VSS sg13g2_nand2_1
X_2063_ _0577_ serializer_inst.fake_adc.skid.data_rg\[0\]
+ _0535_ VDD VSS sg13g2_nand2_1
X_2064_ _0214_ _0576_ _0577_ net553 VDD VSS sg13g2_a21oi_1
X_2065_ _0578_ net515 net507 VDD VSS sg13g2_nor2_1
X_2066_ _0579_ _0785_ _0578_ net497 VDD VSS sg13g2_a21oi_1
X_2067_ _0580_ main_fsm_top_inst.MAIN_TOP_OUTPUTS\[7\] _0579_
+ net564 VDD VSS sg13g2_o21ai_1
X_2068_ _0581_ net511 _0785_ VDD VSS sg13g2_nor2_1
X_2069_ _0582_ _0791_ _0787_ _0581_ VDD VSS sg13g2_nand3_1
X_2070_ _0583_ _0820_ _0582_ VDD VSS sg13g2_nand2_1
X_2071_ _0584_ net533 net512 VDD VSS sg13g2_nor2_1
X_2072_ _0585_ net512 _0580_ _0583_ _0584_ net562 VDD VSS
+ sg13g2_a221oi_1
X_2073_ _0215_ _0585_ VDD VSS sg13g2_inv_1
X_2074_ _0586_ net514 _0581_ _0837_ VDD VSS sg13g2_o21ai_1
X_2075_ _0587_ _0811_ _0586_ net566 VDD VSS sg13g2_nand3b_1
X_2076_ _0588_ net566 net514 _0587_ VDD VSS sg13g2_o21ai_1
X_2077_ _0216_ net562 _0588_ VDD VSS sg13g2_nor2_1
X_2078_ _0589_ net516 _0797_ _0799_ VDD VSS sg13g2_nor3_1
X_2079_ _0590_ net533 _0776_ _0794_ _0589_ VDD VSS sg13g2_nor4_1
X_2080_ _0591_ net566 net516 VDD VSS sg13g2_nor2_1
X_2081_ _0217_ _0590_ _0591_ net532 VDD VSS sg13g2_o21ai_1
X_2082_ _0218_ net554 serializer_inst.fake_adc.sipo_flip_flops\[7\]
+ VDD VSS sg13g2_nor2b_1
X_2083_ _0219_ net555 serializer_inst.fake_adc.sipo_flip_flops\[6\]
+ VDD VSS sg13g2_nor2b_1
X_2084_ _0220_ net555 serializer_inst.fake_adc.sipo_flip_flops\[5\]
+ VDD VSS sg13g2_nor2b_1
X_2085_ _0221_ net555 serializer_inst.fake_adc.sipo_flip_flops\[4\]
+ VDD VSS sg13g2_nor2b_1
X_2086_ _0222_ net555 serializer_inst.fake_adc.sipo_flip_flops\[3\]
+ VDD VSS sg13g2_nor2b_1
X_2087_ _0223_ net554 serializer_inst.fake_adc.sipo_flip_flops\[2\]
+ VDD VSS sg13g2_nor2b_1
X_2088_ _0592_ net479 _0734_ VDD VSS sg13g2_nand2_1
X_2089_ _0593_ net471 _0679_ VDD VSS sg13g2_xnor2_1
X_2090_ _0594_ net479 _0593_ _0708_ VDD VSS sg13g2_nand3b_1
X_2091_ _0225_ _0592_ _0594_ _0224_ VDD VSS sg13g2_a21oi_1
X_2092_ _0595_ main_fsm_top_inst.spi_top_inst.spi_reg.bit_cell2.VALUE_OUT
+ net494 VDD VSS sg13g2_nor2_1
X_2093_ _0596_ main_fsm_top_inst.spi_top_inst.load_in\[1\]
+ main_fsm_top_inst.spi_top_inst.spi_reg.bit_cell1.DATA_OUT
+ _0756_ VDD VSS sg13g2_mux2_1
X_2094_ _0597_ net495 _0596_ VDD VSS sg13g2_nor2_1
X_2095_ _0226_ net539 _0595_ _0597_ VDD VSS sg13g2_nor3_1
X_2096_ _0598_ main_fsm_top_inst.spi_top_inst.spi_reg.bit_cell1.VALUE_OUT
+ net494 VDD VSS sg13g2_nor2_1
X_2097_ _0599_ main_fsm_top_inst.spi_top_inst.load_in\[0\]
+ main_fsm_top_inst.spi_top_inst.spi_reg.bit_cell0.DATA_OUT
+ _0756_ VDD VSS sg13g2_mux2_1
X_2098_ _0600_ net495 _0599_ VDD VSS sg13g2_nor2_1
X_2099_ _0227_ net539 _0598_ _0600_ VDD VSS sg13g2_nor3_1
X_2100_ _0601_ main_fsm_top_inst.spi_top_inst.spi_reg.bit_cell0.VALUE_OUT
+ net493 VDD VSS sg13g2_nand2_1
X_2101_ _0602_ main_fsm_top_inst.spi_top_inst.spi_reg.bit_cell0.DATA_OUT
+ net496 VDD VSS sg13g2_nand2_1
X_2102_ _0228_ _0601_ _0602_ net542 VDD VSS sg13g2_a21oi_1
X_2103_ _0603_ main_fsm_top_inst.spi_top_inst.mosi_sync net494
+ VDD VSS sg13g2_nand2_1
X_2104_ _0604_ main_fsm_top_inst.spi_top_inst.spi_reg.bit_cell0.VALUE_OUT
+ net495 VDD VSS sg13g2_nand2_1
X_2105_ _0229_ _0603_ _0604_ net542 VDD VSS sg13g2_a21oi_1
X_2106_ _0605_ main_fsm_top_inst.spi_top_inst.counter_module.COUNTER\[3\]
+ _0829_ _0480_ VDD VSS sg13g2_nor3_1
X_2107_ _0606_ main_fsm_top_inst.spi_top_inst.counter_module.COUNTER\[3\]
+ _0829_ _0605_ VDD VSS sg13g2_a21oi_1
X_2108_ _0607_ net507 _0606_ VDD VSS sg13g2_nor2_1
X_2109_ _0608_ main_fsm_top_inst.spi_top_inst.counter_module.COUNTER\[3\]
+ _0480_ _0607_ VDD VSS sg13g2_a21oi_1
X_2110_ _0230_ net557 _0608_ VDD VSS sg13g2_nor2_1
X_2111_ _0609_ serializer_inst.piso.piso_flip_flops\[4\] VDD
+ VSS sg13g2_inv_1
X_2112_ _0231_ serializer_inst.freeze_delay net560 _0609_
+ VDD VSS sg13g2_nor3_1
X_2113_ _0232_ main_fsm_top_inst.MAIN_TOP_OUTPUTS\[0\] net501
+ net532 VDD VSS sg13g2_and3_1
X_2114_ _0233_ net553 serializer_inst.fake_adc.sipo_flip_flops\[1\]
+ VDD VSS sg13g2_nor2b_1
X_2115_ _0610_ net508 _0858_ net567 VDD VSS sg13g2_o21ai_1
X_2116_ _0611_ net508 _0778_ main_fsm_top_inst.MAIN_TOP_OUTPUTS\[3\]
+ VDD VSS sg13g2_a21oi_1
X_2117_ _0612_ _0610_ _0611_ _0833_ VDD VSS sg13g2_o21ai_1
X_2118_ _0613_ net567 main_fsm_top_inst.MAIN_TOP_OUTPUTS\[4\]
+ _0858_ VDD VSS sg13g2_nand3_1
X_2119_ _0234_ net532 _0612_ _0613_ VDD VSS sg13g2_and3_1
X_2120_ _0614_ net497 _1002_ net244 VDD VSS sg13g2_o21ai_1
X_2121_ _0615_ net514 net511 VDD VSS sg13g2_xor2_1
X_2122_ _0616_ main_fsm_top_inst.MAIN_TOP_OUTPUTS\[6\] net513
+ VDD VSS sg13g2_and2_1
X_2123_ _0617_ _0795_ net511 VDD VSS sg13g2_nor2_1
X_2124_ _0618_ net244 _0617_ net532 VDD VSS sg13g2_o21ai_1
X_2125_ _0235_ _0789_ _0614_ _0615_ _0616_ _0618_ VDD VSS
+ sg13g2_a221oi_1
X_2126_ _0619_ afe_controller_inst.AFE_CRTL_OUTPUTS\[10\]
+ net502 VDD VSS sg13g2_nand2b_1
X_2127_ _0620_ serializer_inst.freeze_delay serializer_inst.piso.piso_flip_flops\[20\]
+ VDD VSS sg13g2_nand2b_1
X_2128_ _0236_ _0619_ _0620_ net557 VDD VSS sg13g2_a21oi_1
X_2129_ _0009_ clknet_leaf_13_CLK _0181_ net VDD VSS sg13g2_dfrbpq_1
X_2130_ _0010_ clknet_leaf_4_CLK _0180_ net1 VDD VSS sg13g2_dfrbpq_1
X_2131_ _0011_ clknet_leaf_13_CLK _0055_ net2 VDD VSS sg13g2_dfrbpq_1
X_2132_ _0007_ clknet_leaf_3_CLK _0163_ net3 VDD VSS sg13g2_dfrbpq_1
X_2133_ _0008_ clknet_leaf_3_CLK _0162_ net4 VDD VSS sg13g2_dfrbpq_1
Xplace558 net557 net560 VDD VSS sg13g2_buf_1
Xafe_controller_inst.clear$_SDFF_PP0_ afe_controller_inst.clear
+ clknet_leaf_28_CLK _0189_ net5 VDD VSS sg13g2_dfrbpq_1
Xafe_controller_inst.fifo.WE$_DFF_P_ afe_controller_inst.fifo.WE
+ clknet_leaf_29_CLK _0006_ net6 VDD VSS sg13g2_dfrbpq_1
Xafe_controller_inst.fifo.mem\[0\]\[0\]$_SDFFCE_PN0P_ afe_controller_inst.fifo.mem\[0\]\[0\]
+ clknet_leaf_3_CLK _0043_ net7 VDD VSS sg13g2_dfrbpq_1
Xafe_controller_inst.fifo.mem\[0\]\[1\]$_SDFFCE_PN0P_ afe_controller_inst.fifo.mem\[0\]\[1\]
+ clknet_leaf_32_CLK _0042_ net8 VDD VSS sg13g2_dfrbpq_1
Xafe_controller_inst.fifo.mem\[0\]\[2\]$_SDFFCE_PN0P_ afe_controller_inst.fifo.mem\[0\]\[2\]
+ clknet_leaf_0_CLK _0041_ net9 VDD VSS sg13g2_dfrbpq_1
Xafe_controller_inst.fifo.mem\[0\]\[3\]$_SDFFCE_PN0P_ afe_controller_inst.fifo.mem\[0\]\[3\]
+ clknet_leaf_0_CLK _0040_ net10 VDD VSS sg13g2_dfrbpq_1
Xafe_controller_inst.fifo.mem\[0\]\[4\]$_SDFFCE_PN0P_ afe_controller_inst.fifo.mem\[0\]\[4\]
+ clknet_leaf_2_CLK _0039_ net11 VDD VSS sg13g2_dfrbpq_1
Xafe_controller_inst.fifo.mem\[0\]\[5\]$_SDFFCE_PN0P_ afe_controller_inst.fifo.mem\[0\]\[5\]
+ clknet_leaf_1_CLK _0038_ net12 VDD VSS sg13g2_dfrbpq_1
Xafe_controller_inst.fifo.mem\[0\]\[6\]$_SDFFCE_PN0P_ afe_controller_inst.fifo.mem\[0\]\[6\]
+ clknet_leaf_1_CLK _0037_ net13 VDD VSS sg13g2_dfrbpq_1
Xafe_controller_inst.fifo.mem\[0\]\[7\]$_SDFFCE_PN0P_ afe_controller_inst.fifo.mem\[0\]\[7\]
+ clknet_leaf_35_CLK _0202_ net14 VDD VSS sg13g2_dfrbpq_1
Xafe_controller_inst.fifo.mem\[1\]\[0\]$_SDFFCE_PN0P_ afe_controller_inst.fifo.mem\[1\]\[0\]
+ clknet_leaf_3_CLK _0050_ net15 VDD VSS sg13g2_dfrbpq_1
Xafe_controller_inst.fifo.mem\[1\]\[1\]$_SDFFCE_PN0P_ afe_controller_inst.fifo.mem\[1\]\[1\]
+ clknet_leaf_31_CLK _0049_ net16 VDD VSS sg13g2_dfrbpq_1
Xafe_controller_inst.fifo.mem\[1\]\[2\]$_SDFFCE_PN0P_ afe_controller_inst.fifo.mem\[1\]\[2\]
+ clknet_leaf_3_CLK _0048_ net17 VDD VSS sg13g2_dfrbpq_1
Xafe_controller_inst.fifo.mem\[1\]\[3\]$_SDFFCE_PN0P_ afe_controller_inst.fifo.mem\[1\]\[3\]
+ clknet_leaf_0_CLK _0047_ net18 VDD VSS sg13g2_dfrbpq_1
Xafe_controller_inst.fifo.mem\[1\]\[4\]$_SDFFCE_PN0P_ afe_controller_inst.fifo.mem\[1\]\[4\]
+ clknet_leaf_2_CLK _0046_ net19 VDD VSS sg13g2_dfrbpq_1
Xafe_controller_inst.fifo.mem\[1\]\[5\]$_SDFFCE_PN0P_ afe_controller_inst.fifo.mem\[1\]\[5\]
+ clknet_leaf_0_CLK _0045_ net20 VDD VSS sg13g2_dfrbpq_1
Xafe_controller_inst.fifo.mem\[1\]\[6\]$_SDFFCE_PN0P_ afe_controller_inst.fifo.mem\[1\]\[6\]
+ clknet_leaf_1_CLK _0044_ net21 VDD VSS sg13g2_dfrbpq_1
Xafe_controller_inst.fifo.mem\[1\]\[7\]$_SDFFCE_PN0P_ afe_controller_inst.fifo.mem\[1\]\[7\]
+ clknet_leaf_0_CLK _0201_ net22 VDD VSS sg13g2_dfrbpq_1
Xafe_controller_inst.fifo.mem\[2\]\[0\]$_SDFFCE_PN0P_ afe_controller_inst.fifo.mem\[2\]\[0\]
+ clknet_leaf_3_CLK _0058_ net23 VDD VSS sg13g2_dfrbpq_1
Xafe_controller_inst.fifo.mem\[2\]\[1\]$_SDFFCE_PN0P_ afe_controller_inst.fifo.mem\[2\]\[1\]
+ clknet_leaf_31_CLK _0057_ net24 VDD VSS sg13g2_dfrbpq_1
Xafe_controller_inst.fifo.mem\[2\]\[2\]$_SDFFCE_PN0P_ afe_controller_inst.fifo.mem\[2\]\[2\]
+ clknet_leaf_31_CLK _0056_ net25 VDD VSS sg13g2_dfrbpq_1
Xafe_controller_inst.fifo.mem\[2\]\[3\]$_SDFFCE_PN0P_ afe_controller_inst.fifo.mem\[2\]\[3\]
+ clknet_leaf_33_CLK _0054_ net26 VDD VSS sg13g2_dfrbpq_1
Xafe_controller_inst.fifo.mem\[2\]\[4\]$_SDFFCE_PN0P_ afe_controller_inst.fifo.mem\[2\]\[4\]
+ clknet_leaf_2_CLK _0053_ net27 VDD VSS sg13g2_dfrbpq_1
Xafe_controller_inst.fifo.mem\[2\]\[5\]$_SDFFCE_PN0P_ afe_controller_inst.fifo.mem\[2\]\[5\]
+ clknet_leaf_1_CLK _0052_ net28 VDD VSS sg13g2_dfrbpq_1
Xafe_controller_inst.fifo.mem\[2\]\[6\]$_SDFFCE_PN0P_ afe_controller_inst.fifo.mem\[2\]\[6\]
+ clknet_leaf_0_CLK _0051_ net29 VDD VSS sg13g2_dfrbpq_1
Xafe_controller_inst.fifo.mem\[2\]\[7\]$_SDFFCE_PN0P_ afe_controller_inst.fifo.mem\[2\]\[7\]
+ clknet_leaf_35_CLK _0200_ net30 VDD VSS sg13g2_dfrbpq_1
Xafe_controller_inst.fifo.mem\[3\]\[0\]$_SDFFCE_PN0P_ afe_controller_inst.fifo.mem\[3\]\[0\]
+ clknet_leaf_31_CLK _0072_ net31 VDD VSS sg13g2_dfrbpq_1
Xafe_controller_inst.fifo.mem\[3\]\[1\]$_SDFFCE_PN0P_ afe_controller_inst.fifo.mem\[3\]\[1\]
+ clknet_leaf_32_CLK _0071_ net32 VDD VSS sg13g2_dfrbpq_1
Xafe_controller_inst.fifo.mem\[3\]\[2\]$_SDFFCE_PN0P_ afe_controller_inst.fifo.mem\[3\]\[2\]
+ clknet_leaf_33_CLK _0070_ net33 VDD VSS sg13g2_dfrbpq_1
Xafe_controller_inst.fifo.mem\[3\]\[3\]$_SDFFCE_PN0P_ afe_controller_inst.fifo.mem\[3\]\[3\]
+ clknet_leaf_33_CLK _0067_ net34 VDD VSS sg13g2_dfrbpq_1
Xafe_controller_inst.fifo.mem\[3\]\[4\]$_SDFFCE_PN0P_ afe_controller_inst.fifo.mem\[3\]\[4\]
+ clknet_leaf_1_CLK _0064_ net35 VDD VSS sg13g2_dfrbpq_1
Xafe_controller_inst.fifo.mem\[3\]\[5\]$_SDFFCE_PN0P_ afe_controller_inst.fifo.mem\[3\]\[5\]
+ clknet_leaf_1_CLK _0063_ net36 VDD VSS sg13g2_dfrbpq_1
Xafe_controller_inst.fifo.mem\[3\]\[6\]$_SDFFCE_PN0P_ afe_controller_inst.fifo.mem\[3\]\[6\]
+ clknet_leaf_0_CLK _0059_ net37 VDD VSS sg13g2_dfrbpq_1
Xafe_controller_inst.fifo.mem\[3\]\[7\]$_SDFFCE_PN0P_ afe_controller_inst.fifo.mem\[3\]\[7\]
+ clknet_leaf_35_CLK _0199_ net38 VDD VSS sg13g2_dfrbpq_1
Xafe_controller_inst.fifo.r_ptr\[0\]$_SDFFE_PP0P_ afe_controller_inst.fifo.r_ptr\[0\]
+ clknet_leaf_30_CLK _0163_ net39 VDD VSS sg13g2_dfrbpq_1
Xafe_controller_inst.fifo.r_ptr\[1\]$_SDFFE_PP0P_ afe_controller_inst.fifo.r_ptr\[1\]
+ clknet_leaf_30_CLK _0162_ net40 VDD VSS sg13g2_dfrbpq_1
Xafe_controller_inst.fifo.r_ptr\[2\]$_SDFFE_PP0P_ afe_controller_inst.fifo.r_ptr\[2\]
+ clknet_leaf_30_CLK _0126_ net41 VDD VSS sg13g2_dfrbpq_1
Xafe_controller_inst.fifo.w_ptr\[0\]$_SDFFE_PP0P_ afe_controller_inst.fifo.w_ptr\[0\]
+ clknet_leaf_28_CLK _0161_ net42 VDD VSS sg13g2_dfrbpq_1
Xafe_controller_inst.fifo.w_ptr\[1\]$_SDFFE_PP0P_ afe_controller_inst.fifo.w_ptr\[1\]
+ clknet_leaf_30_CLK _0160_ net43 VDD VSS sg13g2_dfrbpq_1
Xafe_controller_inst.fifo.w_ptr\[2\]$_SDFFE_PP0P_ afe_controller_inst.fifo.w_ptr\[2\]
+ clknet_leaf_31_CLK _0179_ net44 VDD VSS sg13g2_dfrbpq_1
Xafe_controller_inst.fifo_in_sel\[0\]$_DFF_P_ afe_controller_inst.fifo_in_sel\[0\]
+ clknet_leaf_28_CLK _0004_ net45 VDD VSS sg13g2_dfrbpq_1
Xafe_controller_inst.fifo_in_sel\[1\]$_DFF_P_ afe_controller_inst.fifo_in_sel\[1\]
+ clknet_leaf_27_CLK _0005_ net46 VDD VSS sg13g2_dfrbpq_1
Xafe_controller_inst.fsm.state\[0\]$_SDFFE_PP0P_ afe_controller_inst.AFE_CRTL_OUTPUTS\[0\]
+ clknet_leaf_26_CLK net479 net47 VDD VSS sg13g2_dfrbpq_1
Xafe_controller_inst.fsm.state\[1\]$_SDFFE_PP0P_ afe_controller_inst.AFE_CRTL_OUTPUTS\[1\]
+ clknet_leaf_26_CLK _0158_ net48 VDD VSS sg13g2_dfrbpq_1
Xafe_controller_inst.fsm.state\[2\]$_SDFFE_PP0P_ afe_controller_inst.AFE_CRTL_OUTPUTS\[2\]
+ clknet_leaf_29_CLK net472 net49 VDD VSS sg13g2_dfrbpq_1
Xafe_controller_inst.fsm.state\[3\]$_SDFFE_PP0P_ afe_controller_inst.AFE_CRTL_OUTPUTS\[3\]
+ clknet_leaf_27_CLK _0144_ net50 VDD VSS sg13g2_dfrbpq_1
Xafe_controller_inst.fsm.state\[4\]$_SDFFE_PP0P_ afe_controller_inst.AFE_CRTL_OUTPUTS\[4\]
+ clknet_leaf_25_CLK _0224_ net51 VDD VSS sg13g2_dfrbpq_1
Xafe_controller_inst.valid_control.state$_SDFFE_PP0P_ afe_controller_inst.valid_control.state
+ clknet_leaf_30_CLK _0012_ net52 VDD VSS sg13g2_dfrbpq_1
Xmain_fsm_top_inst.Register_File_inst.registers\[0\]\[0\]$_SDFFCE_PN1P_
+ main_fsm_top_inst.Register_File_inst.registers\[0\]\[0\] clknet_leaf_6_CLK
+ _0083_ net53 VDD VSS sg13g2_dfrbpq_1
Xmain_fsm_top_inst.Register_File_inst.registers\[0\]\[1\]$_SDFFCE_PN1P_
+ main_fsm_top_inst.Register_File_inst.registers\[0\]\[1\] clknet_leaf_11_CLK
+ _0082_ net54 VDD VSS sg13g2_dfrbpq_1
Xmain_fsm_top_inst.Register_File_inst.registers\[0\]\[2\]$_SDFFCE_PN1P_
+ main_fsm_top_inst.Register_File_inst.registers\[0\]\[2\] clknet_leaf_6_CLK
+ _0081_ net55 VDD VSS sg13g2_dfrbpq_1
Xmain_fsm_top_inst.Register_File_inst.registers\[0\]\[3\]$_SDFFCE_PN0P_
+ main_fsm_top_inst.Register_File_inst.registers\[0\]\[3\] clknet_leaf_10_CLK
+ _0080_ net56 VDD VSS sg13g2_dfrbpq_1
Xmain_fsm_top_inst.Register_File_inst.registers\[0\]\[4\]$_SDFFCE_PN1P_
+ main_fsm_top_inst.Register_File_inst.registers\[0\]\[4\] clknet_leaf_4_CLK
+ _0079_ net57 VDD VSS sg13g2_dfrbpq_1
Xmain_fsm_top_inst.Register_File_inst.registers\[0\]\[5\]$_SDFFCE_PN0P_
+ main_fsm_top_inst.Register_File_inst.registers\[0\]\[5\] clknet_leaf_8_CLK
+ _0077_ net58 VDD VSS sg13g2_dfrbpq_1
Xmain_fsm_top_inst.Register_File_inst.registers\[0\]\[6\]$_SDFFCE_PN1P_
+ main_fsm_top_inst.Register_File_inst.registers\[0\]\[6\] clknet_leaf_8_CLK
+ _0075_ net59 VDD VSS sg13g2_dfrbpq_1
Xmain_fsm_top_inst.Register_File_inst.registers\[0\]\[7\]$_SDFFCE_PN1P_
+ main_fsm_top_inst.Register_File_inst.registers\[0\]\[7\] clknet_leaf_1_CLK
+ _0157_ net60 VDD VSS sg13g2_dfrbpq_1
Xmain_fsm_top_inst.Register_File_inst.registers\[1\]\[0\]$_SDFFCE_PN0P_
+ main_fsm_top_inst.Register_File_inst.registers\[1\]\[0\] clknet_leaf_7_CLK
+ _0090_ net61 VDD VSS sg13g2_dfrbpq_1
Xmain_fsm_top_inst.Register_File_inst.registers\[1\]\[1\]$_SDFFCE_PN0P_
+ main_fsm_top_inst.Register_File_inst.registers\[1\]\[1\] clknet_leaf_11_CLK
+ _0089_ net62 VDD VSS sg13g2_dfrbpq_1
Xmain_fsm_top_inst.Register_File_inst.registers\[1\]\[2\]$_SDFFCE_PN0P_
+ main_fsm_top_inst.Register_File_inst.registers\[1\]\[2\] clknet_leaf_6_CLK
+ _0088_ net63 VDD VSS sg13g2_dfrbpq_1
Xmain_fsm_top_inst.Register_File_inst.registers\[1\]\[3\]$_SDFFCE_PN0P_
+ main_fsm_top_inst.Register_File_inst.registers\[1\]\[3\] clknet_leaf_10_CLK
+ _0087_ net64 VDD VSS sg13g2_dfrbpq_1
Xmain_fsm_top_inst.Register_File_inst.registers\[1\]\[4\]$_SDFFCE_PN0P_
+ main_fsm_top_inst.Register_File_inst.registers\[1\]\[4\] clknet_leaf_12_CLK
+ _0086_ net65 VDD VSS sg13g2_dfrbpq_1
Xmain_fsm_top_inst.Register_File_inst.registers\[1\]\[5\]$_SDFFCE_PN0P_
+ main_fsm_top_inst.Register_File_inst.registers\[1\]\[5\] clknet_leaf_8_CLK
+ _0085_ net66 VDD VSS sg13g2_dfrbpq_1
Xmain_fsm_top_inst.Register_File_inst.registers\[1\]\[6\]$_SDFFCE_PN0P_
+ main_fsm_top_inst.Register_File_inst.registers\[1\]\[6\] clknet_leaf_9_CLK
+ _0084_ net67 VDD VSS sg13g2_dfrbpq_1
Xmain_fsm_top_inst.Register_File_inst.registers\[1\]\[7\]$_SDFFCE_PN0P_
+ main_fsm_top_inst.Register_File_inst.registers\[1\]\[7\] clknet_leaf_5_CLK
+ _0155_ net68 VDD VSS sg13g2_dfrbpq_1
Xmain_fsm_top_inst.Register_File_inst.registers\[2\]\[0\]$_SDFFCE_PN0P_
+ main_fsm_top_inst.Register_File_inst.registers\[2\]\[0\] clknet_leaf_7_CLK
+ _0097_ net69 VDD VSS sg13g2_dfrbpq_1
Xmain_fsm_top_inst.Register_File_inst.registers\[2\]\[1\]$_SDFFCE_PN0P_
+ main_fsm_top_inst.Register_File_inst.registers\[2\]\[1\] clknet_leaf_11_CLK
+ _0096_ net70 VDD VSS sg13g2_dfrbpq_1
Xmain_fsm_top_inst.Register_File_inst.registers\[2\]\[2\]$_SDFFCE_PN0P_
+ main_fsm_top_inst.Register_File_inst.registers\[2\]\[2\] clknet_leaf_6_CLK
+ _0095_ net71 VDD VSS sg13g2_dfrbpq_1
Xmain_fsm_top_inst.Register_File_inst.registers\[2\]\[3\]$_SDFFCE_PN0P_
+ main_fsm_top_inst.Register_File_inst.registers\[2\]\[3\] clknet_leaf_10_CLK
+ _0094_ net72 VDD VSS sg13g2_dfrbpq_1
Xmain_fsm_top_inst.Register_File_inst.registers\[2\]\[4\]$_SDFFCE_PN0P_
+ main_fsm_top_inst.Register_File_inst.registers\[2\]\[4\] clknet_leaf_12_CLK
+ _0093_ net73 VDD VSS sg13g2_dfrbpq_1
Xmain_fsm_top_inst.Register_File_inst.registers\[2\]\[5\]$_SDFFCE_PN0P_
+ main_fsm_top_inst.Register_File_inst.registers\[2\]\[5\] clknet_leaf_8_CLK
+ _0092_ net74 VDD VSS sg13g2_dfrbpq_1
Xmain_fsm_top_inst.Register_File_inst.registers\[2\]\[6\]$_SDFFCE_PN0P_
+ main_fsm_top_inst.Register_File_inst.registers\[2\]\[6\] clknet_leaf_8_CLK
+ _0091_ net75 VDD VSS sg13g2_dfrbpq_1
Xmain_fsm_top_inst.Register_File_inst.registers\[2\]\[7\]$_SDFFCE_PN0P_
+ main_fsm_top_inst.Register_File_inst.registers\[2\]\[7\] clknet_leaf_5_CLK
+ _0154_ net76 VDD VSS sg13g2_dfrbpq_1
Xmain_fsm_top_inst.Register_File_inst.registers\[3\]\[0\]$_SDFFCE_PN0P_
+ main_fsm_top_inst.Register_File_inst.registers\[3\]\[0\] clknet_leaf_7_CLK
+ _0104_ net77 VDD VSS sg13g2_dfrbpq_1
Xmain_fsm_top_inst.Register_File_inst.registers\[3\]\[1\]$_SDFFCE_PN0P_
+ main_fsm_top_inst.Register_File_inst.registers\[3\]\[1\] clknet_leaf_11_CLK
+ _0103_ net78 VDD VSS sg13g2_dfrbpq_1
Xmain_fsm_top_inst.Register_File_inst.registers\[3\]\[2\]$_SDFFCE_PN0P_
+ main_fsm_top_inst.Register_File_inst.registers\[3\]\[2\] clknet_leaf_6_CLK
+ _0102_ net79 VDD VSS sg13g2_dfrbpq_1
Xmain_fsm_top_inst.Register_File_inst.registers\[3\]\[3\]$_SDFFCE_PN0P_
+ main_fsm_top_inst.Register_File_inst.registers\[3\]\[3\] clknet_leaf_10_CLK
+ _0101_ net80 VDD VSS sg13g2_dfrbpq_1
Xmain_fsm_top_inst.Register_File_inst.registers\[3\]\[4\]$_SDFFCE_PN0P_
+ main_fsm_top_inst.Register_File_inst.registers\[3\]\[4\] clknet_leaf_12_CLK
+ _0100_ net81 VDD VSS sg13g2_dfrbpq_1
Xmain_fsm_top_inst.Register_File_inst.registers\[3\]\[5\]$_SDFFCE_PN0P_
+ main_fsm_top_inst.Register_File_inst.registers\[3\]\[5\] clknet_leaf_8_CLK
+ _0099_ net82 VDD VSS sg13g2_dfrbpq_1
Xmain_fsm_top_inst.Register_File_inst.registers\[3\]\[6\]$_SDFFCE_PN0P_
+ main_fsm_top_inst.Register_File_inst.registers\[3\]\[6\] clknet_leaf_9_CLK
+ _0098_ net83 VDD VSS sg13g2_dfrbpq_1
Xmain_fsm_top_inst.Register_File_inst.registers\[3\]\[7\]$_SDFFCE_PN0P_
+ main_fsm_top_inst.Register_File_inst.registers\[3\]\[7\] clknet_leaf_5_CLK
+ _0153_ net84 VDD VSS sg13g2_dfrbpq_1
Xmain_fsm_top_inst.Register_File_inst.registers\[4\]\[0\]$_SDFFCE_PN0P_
+ main_fsm_top_inst.Register_File_inst.registers\[4\]\[0\] clknet_leaf_5_CLK
+ _0111_ net85 VDD VSS sg13g2_dfrbpq_1
Xmain_fsm_top_inst.Register_File_inst.registers\[4\]\[1\]$_SDFFCE_PN0P_
+ main_fsm_top_inst.Register_File_inst.registers\[4\]\[1\] clknet_leaf_11_CLK
+ _0110_ net86 VDD VSS sg13g2_dfrbpq_1
Xmain_fsm_top_inst.Register_File_inst.registers\[4\]\[2\]$_SDFFCE_PN0P_
+ main_fsm_top_inst.Register_File_inst.registers\[4\]\[2\] clknet_leaf_6_CLK
+ _0109_ net87 VDD VSS sg13g2_dfrbpq_1
Xmain_fsm_top_inst.Register_File_inst.registers\[4\]\[3\]$_SDFFCE_PN0P_
+ main_fsm_top_inst.Register_File_inst.registers\[4\]\[3\] clknet_leaf_10_CLK
+ _0108_ net88 VDD VSS sg13g2_dfrbpq_1
Xmain_fsm_top_inst.Register_File_inst.registers\[4\]\[4\]$_SDFFCE_PN0P_
+ main_fsm_top_inst.Register_File_inst.registers\[4\]\[4\] clknet_leaf_12_CLK
+ _0107_ net89 VDD VSS sg13g2_dfrbpq_1
Xmain_fsm_top_inst.Register_File_inst.registers\[4\]\[5\]$_SDFFCE_PN0P_
+ main_fsm_top_inst.Register_File_inst.registers\[4\]\[5\] clknet_leaf_7_CLK
+ _0106_ net90 VDD VSS sg13g2_dfrbpq_1
Xmain_fsm_top_inst.Register_File_inst.registers\[4\]\[6\]$_SDFFCE_PN0P_
+ main_fsm_top_inst.Register_File_inst.registers\[4\]\[6\] clknet_leaf_7_CLK
+ _0105_ net91 VDD VSS sg13g2_dfrbpq_1
Xmain_fsm_top_inst.Register_File_inst.registers\[4\]\[7\]$_SDFFCE_PN0P_
+ main_fsm_top_inst.Register_File_inst.registers\[4\]\[7\] clknet_leaf_5_CLK
+ _0152_ net92 VDD VSS sg13g2_dfrbpq_1
Xmain_fsm_top_inst.Register_File_inst.registers\[5\]\[0\]$_SDFFCE_PN0P_
+ main_fsm_top_inst.Register_File_inst.registers\[5\]\[0\] clknet_leaf_5_CLK
+ _0119_ net93 VDD VSS sg13g2_dfrbpq_1
Xmain_fsm_top_inst.Register_File_inst.registers\[5\]\[1\]$_SDFFCE_PN0P_
+ main_fsm_top_inst.Register_File_inst.registers\[5\]\[1\] clknet_leaf_12_CLK
+ _0118_ net94 VDD VSS sg13g2_dfrbpq_1
Xmain_fsm_top_inst.Register_File_inst.registers\[5\]\[2\]$_SDFFCE_PN0P_
+ main_fsm_top_inst.Register_File_inst.registers\[5\]\[2\] clknet_leaf_6_CLK
+ _0117_ net95 VDD VSS sg13g2_dfrbpq_1
Xmain_fsm_top_inst.Register_File_inst.registers\[5\]\[3\]$_SDFFCE_PN0P_
+ main_fsm_top_inst.Register_File_inst.registers\[5\]\[3\] clknet_leaf_10_CLK
+ _0116_ net96 VDD VSS sg13g2_dfrbpq_1
Xmain_fsm_top_inst.Register_File_inst.registers\[5\]\[4\]$_SDFFCE_PN0P_
+ main_fsm_top_inst.Register_File_inst.registers\[5\]\[4\] clknet_leaf_4_CLK
+ _0115_ net97 VDD VSS sg13g2_dfrbpq_1
Xmain_fsm_top_inst.Register_File_inst.registers\[5\]\[5\]$_SDFFCE_PN0P_
+ main_fsm_top_inst.Register_File_inst.registers\[5\]\[5\] clknet_leaf_8_CLK
+ _0114_ net98 VDD VSS sg13g2_dfrbpq_1
Xmain_fsm_top_inst.Register_File_inst.registers\[5\]\[6\]$_SDFFCE_PN0P_
+ main_fsm_top_inst.Register_File_inst.registers\[5\]\[6\] clknet_leaf_9_CLK
+ _0113_ net99 VDD VSS sg13g2_dfrbpq_1
Xmain_fsm_top_inst.Register_File_inst.registers\[5\]\[7\]$_SDFFCE_PN0P_
+ main_fsm_top_inst.Register_File_inst.registers\[5\]\[7\] clknet_leaf_5_CLK
+ _0151_ net100 VDD VSS sg13g2_dfrbpq_1
Xmain_fsm_top_inst.Register_File_inst.registers\[6\]\[0\]$_SDFFCE_PN0P_
+ main_fsm_top_inst.Register_File_inst.registers\[6\]\[0\] clknet_leaf_2_CLK
+ _0133_ net101 VDD VSS sg13g2_dfrbpq_1
Xmain_fsm_top_inst.Register_File_inst.registers\[6\]\[1\]$_SDFFCE_PN0P_
+ main_fsm_top_inst.Register_File_inst.registers\[6\]\[1\] clknet_leaf_11_CLK
+ _0132_ net102 VDD VSS sg13g2_dfrbpq_1
Xmain_fsm_top_inst.Register_File_inst.registers\[6\]\[2\]$_SDFFCE_PN0P_
+ main_fsm_top_inst.Register_File_inst.registers\[6\]\[2\] clknet_leaf_1_CLK
+ _0129_ net103 VDD VSS sg13g2_dfrbpq_1
Xmain_fsm_top_inst.Register_File_inst.registers\[6\]\[3\]$_SDFFCE_PN0P_
+ main_fsm_top_inst.Register_File_inst.registers\[6\]\[3\] clknet_leaf_10_CLK
+ _0125_ net104 VDD VSS sg13g2_dfrbpq_1
Xmain_fsm_top_inst.Register_File_inst.registers\[6\]\[4\]$_SDFFCE_PN0P_
+ main_fsm_top_inst.Register_File_inst.registers\[6\]\[4\] clknet_leaf_12_CLK
+ _0124_ net105 VDD VSS sg13g2_dfrbpq_1
Xmain_fsm_top_inst.Register_File_inst.registers\[6\]\[5\]$_SDFFCE_PN0P_
+ main_fsm_top_inst.Register_File_inst.registers\[6\]\[5\] clknet_leaf_8_CLK
+ _0123_ net106 VDD VSS sg13g2_dfrbpq_1
Xmain_fsm_top_inst.Register_File_inst.registers\[6\]\[6\]$_SDFFCE_PN0P_
+ main_fsm_top_inst.Register_File_inst.registers\[6\]\[6\] clknet_leaf_9_CLK
+ _0122_ net107 VDD VSS sg13g2_dfrbpq_1
Xmain_fsm_top_inst.Register_File_inst.registers\[6\]\[7\]$_SDFFCE_PN0P_
+ main_fsm_top_inst.Register_File_inst.registers\[6\]\[7\] clknet_leaf_2_CLK
+ _0150_ net108 VDD VSS sg13g2_dfrbpq_1
Xmain_fsm_top_inst.Register_File_inst.registers\[7\]\[0\]$_SDFFCE_PN0P_
+ main_fsm_top_inst.Register_File_inst.registers\[7\]\[0\] clknet_leaf_5_CLK
+ _0141_ net109 VDD VSS sg13g2_dfrbpq_1
Xmain_fsm_top_inst.Register_File_inst.registers\[7\]\[1\]$_SDFFCE_PN0P_
+ main_fsm_top_inst.Register_File_inst.registers\[7\]\[1\] clknet_leaf_11_CLK
+ _0139_ net110 VDD VSS sg13g2_dfrbpq_1
Xmain_fsm_top_inst.Register_File_inst.registers\[7\]\[2\]$_SDFFCE_PN0P_
+ main_fsm_top_inst.Register_File_inst.registers\[7\]\[2\] clknet_leaf_6_CLK
+ _0138_ net111 VDD VSS sg13g2_dfrbpq_1
Xmain_fsm_top_inst.Register_File_inst.registers\[7\]\[3\]$_SDFFCE_PN0P_
+ main_fsm_top_inst.Register_File_inst.registers\[7\]\[3\] clknet_leaf_12_CLK
+ _0137_ net112 VDD VSS sg13g2_dfrbpq_1
Xmain_fsm_top_inst.Register_File_inst.registers\[7\]\[4\]$_SDFFCE_PN0P_
+ main_fsm_top_inst.Register_File_inst.registers\[7\]\[4\] clknet_leaf_12_CLK
+ _0136_ net113 VDD VSS sg13g2_dfrbpq_1
Xmain_fsm_top_inst.Register_File_inst.registers\[7\]\[5\]$_SDFFCE_PN0P_
+ main_fsm_top_inst.Register_File_inst.registers\[7\]\[5\] clknet_leaf_7_CLK
+ _0135_ net114 VDD VSS sg13g2_dfrbpq_1
Xmain_fsm_top_inst.Register_File_inst.registers\[7\]\[6\]$_SDFFCE_PN0P_
+ main_fsm_top_inst.Register_File_inst.registers\[7\]\[6\] clknet_leaf_9_CLK
+ _0134_ net115 VDD VSS sg13g2_dfrbpq_1
Xmain_fsm_top_inst.Register_File_inst.registers\[7\]\[7\]$_SDFFCE_PN0P_
+ main_fsm_top_inst.Register_File_inst.registers\[7\]\[7\] clknet_leaf_4_CLK
+ _0148_ net116 VDD VSS sg13g2_dfrbpq_1
Xmain_fsm_top_inst.cfg_register_inst.data\[0\]$_SDFFE_PP0P_
+ afe_controller_inst.CONFIG_VALUES\[0\] clknet_leaf_3_CLK _0177_
+ net117 VDD VSS sg13g2_dfrbpq_1
Xmain_fsm_top_inst.cfg_register_inst.data\[1\]$_SDFFE_PP0P_
+ afe_controller_inst.AFE_CRTL_OUTPUTS\[10\] clknet_leaf_4_CLK
+ _0175_ net118 VDD VSS sg13g2_dfrbpq_1
Xmain_fsm_top_inst.cfg_register_inst.data\[2\]$_SDFFE_PP0P_
+ afe_controller_inst.CONFIG_VALUES\[2\] clknet_leaf_4_CLK _0178_
+ net119 VDD VSS sg13g2_dfrbpq_1
Xmain_fsm_top_inst.cfg_register_inst.data\[3\]$_SDFFE_PP0P_
+ afe_controller_inst.CONFIG_VALUES\[3\] clknet_leaf_3_CLK _0176_
+ net120 VDD VSS sg13g2_dfrbpq_1
Xmain_fsm_top_inst.cfg_register_inst.data\[4\]$_SDFFE_PP0P_
+ afe_controller_inst.CONFIG_VALUES\[4\] clknet_leaf_4_CLK _0149_
+ net121 VDD VSS sg13g2_dfrbpq_1
Xmain_fsm_top_inst.main_fsm_inst.current_state\[0\]$_SDFFE_PP1P_
+ main_fsm_top_inst.MAIN_TOP_OUTPUTS\[6\] clknet_leaf_30_CLK
+ _0217_ net122 VDD VSS sg13g2_dfrbpq_1
Xmain_fsm_top_inst.main_fsm_inst.current_state\[1\]$_SDFFE_PP0P_
+ main_fsm_top_inst.MAIN_TOP_OUTPUTS\[7\] clknet_leaf_23_CLK
+ _0216_ net123 VDD VSS sg13g2_dfrbpq_1
Xmain_fsm_top_inst.main_fsm_inst.current_state\[2\]$_SDFFE_PP1P_
+ main_fsm_top_inst.MAIN_TOP_OUTPUTS\[8\] clknet_leaf_30_CLK
+ _0215_ net124 VDD VSS sg13g2_dfrbpq_1
Xmain_fsm_top_inst.main_fsm_inst.current_state\[3\]$_SDFFE_PP1P_
+ main_fsm_top_inst.MAIN_TOP_OUTPUTS\[9\] clknet_leaf_21_CLK
+ _0156_ net125 VDD VSS sg13g2_dfrbpq_1
Xmain_fsm_top_inst.main_fsm_inst.fsm_data_rdy_flag$_SDFFE_PP0P_
+ net244 clknet_3_6__leaf_CLK _0235_ net126 VDD VSS sg13g2_dfrbpq_1
Xmain_fsm_top_inst.pointer_register_inst.data_out\[0\]$_SDFFE_PP0N_
+ main_fsm_top_inst.Register_File_inst.r_addr\[0\] clknet_leaf_13_CLK
+ _0181_ net127 VDD VSS sg13g2_dfrbpq_1
Xmain_fsm_top_inst.pointer_register_inst.data_out\[1\]$_SDFFE_PP0N_
+ main_fsm_top_inst.Register_File_inst.r_addr\[1\] clknet_leaf_4_CLK
+ _0180_ net128 VDD VSS sg13g2_dfrbpq_1
Xmain_fsm_top_inst.pointer_register_inst.data_out\[2\]$_SDFFE_PP0N_
+ main_fsm_top_inst.Register_File_inst.r_addr\[2\] clknet_leaf_13_CLK
+ _0055_ net129 VDD VSS sg13g2_dfrbpq_1
Xmain_fsm_top_inst.spi_rx.bypass_rg$_SDFF_PP1_ main_fsm_top_inst.spi_dout_rdy_sig
+ clknet_leaf_23_CLK _0112_ net130 VDD VSS sg13g2_dfrbpq_1
Xmain_fsm_top_inst.spi_rx.data_rg\[0\]$_SDFFE_PP0P_ main_fsm_top_inst.spi_rx.data_rg\[0\]
+ clknet_leaf_21_CLK _0204_ net131 VDD VSS sg13g2_dfrbpq_1
Xmain_fsm_top_inst.spi_rx.data_rg\[1\]$_SDFFE_PP0P_ main_fsm_top_inst.spi_rx.data_rg\[1\]
+ clknet_leaf_19_CLK _0203_ net132 VDD VSS sg13g2_dfrbpq_1
Xmain_fsm_top_inst.spi_rx.data_rg\[2\]$_SDFFE_PP0P_ main_fsm_top_inst.spi_rx.data_rg\[2\]
+ clknet_leaf_18_CLK _0198_ net133 VDD VSS sg13g2_dfrbpq_1
Xmain_fsm_top_inst.spi_rx.data_rg\[3\]$_SDFFE_PP0P_ main_fsm_top_inst.spi_rx.data_rg\[3\]
+ clknet_leaf_19_CLK _0195_ net134 VDD VSS sg13g2_dfrbpq_1
Xmain_fsm_top_inst.spi_rx.data_rg\[4\]$_SDFFE_PP0P_ main_fsm_top_inst.spi_rx.data_rg\[4\]
+ clknet_leaf_21_CLK _0194_ net135 VDD VSS sg13g2_dfrbpq_1
Xmain_fsm_top_inst.spi_rx.data_rg\[5\]$_SDFFE_PP0P_ main_fsm_top_inst.spi_rx.data_rg\[5\]
+ clknet_leaf_14_CLK _0193_ net136 VDD VSS sg13g2_dfrbpq_1
Xmain_fsm_top_inst.spi_rx.data_rg\[6\]$_SDFFE_PP0P_ main_fsm_top_inst.spi_rx.data_rg\[6\]
+ clknet_leaf_19_CLK _0190_ net137 VDD VSS sg13g2_dfrbpq_1
Xmain_fsm_top_inst.spi_rx.data_rg\[7\]$_SDFFE_PP0P_ main_fsm_top_inst.spi_rx.data_rg\[7\]
+ clknet_leaf_18_CLK _0076_ net138 VDD VSS sg13g2_dfrbpq_1
Xmain_fsm_top_inst.spi_top_inst.counter_module.counter\[0\]$_SDFFE_PP0P_
+ main_fsm_top_inst.spi_top_inst.counter_module.COUNTER\[0\]
+ clknet_leaf_20_CLK _0174_ net139 VDD VSS sg13g2_dfrbpq_1
Xmain_fsm_top_inst.spi_top_inst.counter_module.counter\[1\]$_SDFFE_PP0P_
+ main_fsm_top_inst.spi_top_inst.counter_module.COUNTER\[1\]
+ clknet_leaf_20_CLK _0173_ net140 VDD VSS sg13g2_dfrbpq_1
Xmain_fsm_top_inst.spi_top_inst.counter_module.counter\[2\]$_SDFFE_PP0P_
+ main_fsm_top_inst.spi_top_inst.counter_module.COUNTER\[2\]
+ clknet_leaf_20_CLK _0171_ net141 VDD VSS sg13g2_dfrbpq_1
Xmain_fsm_top_inst.spi_top_inst.counter_module.counter\[3\]$_SDFFE_PP0P_
+ main_fsm_top_inst.spi_top_inst.counter_module.COUNTER\[3\]
+ clknet_leaf_19_CLK _0230_ net142 VDD VSS sg13g2_dfrbpq_1
Xmain_fsm_top_inst.spi_top_inst.cs_meta$_SDFF_PP0_ main_fsm_top_inst.spi_top_inst.cs_meta
+ clknet_leaf_15_CLK _0172_ net143 VDD VSS sg13g2_dfrbpq_1
Xmain_fsm_top_inst.spi_top_inst.cs_sync$_SDFF_PP0_ afe_controller_inst.CONFIG_VALID
+ clknet_leaf_14_CLK _0131_ net144 VDD VSS sg13g2_dfrbpq_1
Xmain_fsm_top_inst.spi_top_inst.edge_dummy$_SDFF_PP0_ main_fsm_top_inst.spi_top_inst.edge_dummy
+ clknet_leaf_13_CLK _0128_ net145 VDD VSS sg13g2_dfrbpq_1
Xmain_fsm_top_inst.spi_top_inst.fsm.downstream_state\[0\]$_SDFFE_PP0P_
+ main_fsm_top_inst.MAIN_TOP_OUTPUTS\[0\] clknet_leaf_21_CLK
+ _0017_ net146 VDD VSS sg13g2_dfrbpq_1
Xmain_fsm_top_inst.spi_top_inst.fsm.downstream_state\[1\]$_SDFFE_PP0P_
+ main_fsm_top_inst.MAIN_TOP_OUTPUTS\[1\] clknet_leaf_21_CLK
+ _0211_ net147 VDD VSS sg13g2_dfrbpq_1
Xmain_fsm_top_inst.spi_top_inst.fsm.upstream_state\[0\]$_SDFFE_PP0P_
+ main_fsm_top_inst.MAIN_TOP_OUTPUTS\[3\] clknet_leaf_19_CLK
+ _0016_ net148 VDD VSS sg13g2_dfrbpq_1
Xmain_fsm_top_inst.spi_top_inst.fsm.upstream_state\[1\]$_SDFFE_PP0P_
+ main_fsm_top_inst.MAIN_TOP_OUTPUTS\[4\] clknet_leaf_20_CLK
+ _0234_ net149 VDD VSS sg13g2_dfrbpq_1
Xmain_fsm_top_inst.spi_top_inst.load_in\[0\]$_SDFFE_PP0P_
+ main_fsm_top_inst.spi_top_inst.load_in\[0\] clknet_leaf_16_CLK
+ _0170_ net150 VDD VSS sg13g2_dfrbpq_1
Xmain_fsm_top_inst.spi_top_inst.load_in\[1\]$_SDFFE_PP0P_
+ main_fsm_top_inst.spi_top_inst.load_in\[1\] clknet_leaf_16_CLK
+ _0169_ net151 VDD VSS sg13g2_dfrbpq_1
Xmain_fsm_top_inst.spi_top_inst.load_in\[2\]$_SDFFE_PP0P_
+ main_fsm_top_inst.spi_top_inst.load_in\[2\] clknet_leaf_15_CLK
+ _0168_ net152 VDD VSS sg13g2_dfrbpq_1
Xmain_fsm_top_inst.spi_top_inst.load_in\[3\]$_SDFFE_PP0P_
+ main_fsm_top_inst.spi_top_inst.load_in\[3\] clknet_leaf_17_CLK
+ _0167_ net153 VDD VSS sg13g2_dfrbpq_1
Xmain_fsm_top_inst.spi_top_inst.load_in\[4\]$_SDFFE_PP0P_
+ main_fsm_top_inst.spi_top_inst.load_in\[4\] clknet_leaf_14_CLK
+ _0166_ net154 VDD VSS sg13g2_dfrbpq_1
Xmain_fsm_top_inst.spi_top_inst.load_in\[5\]$_SDFFE_PP0P_
+ main_fsm_top_inst.spi_top_inst.load_in\[5\] clknet_leaf_17_CLK
+ _0165_ net155 VDD VSS sg13g2_dfrbpq_1
Xmain_fsm_top_inst.spi_top_inst.load_in\[6\]$_SDFFE_PP0P_
+ main_fsm_top_inst.spi_top_inst.load_in\[6\] clknet_leaf_17_CLK
+ _0164_ net156 VDD VSS sg13g2_dfrbpq_1
Xmain_fsm_top_inst.spi_top_inst.load_in\[7\]$_SDFFE_PP0P_
+ main_fsm_top_inst.spi_top_inst.load_in\[7\] clknet_leaf_15_CLK
+ _0127_ net157 VDD VSS sg13g2_dfrbpq_1
Xmain_fsm_top_inst.spi_top_inst.mosi_meta$_SDFF_PP0_ main_fsm_top_inst.spi_top_inst.mosi_meta
+ clknet_leaf_10_CLK _0142_ net158 VDD VSS sg13g2_dfrbpq_1
Xmain_fsm_top_inst.spi_top_inst.mosi_sync$_SDFF_PP0_ main_fsm_top_inst.spi_top_inst.mosi_sync
+ clknet_leaf_16_CLK _0130_ net159 VDD VSS sg13g2_dfrbpq_1
Xmain_fsm_top_inst.spi_top_inst.sck_meta$_SDFF_PP0_ main_fsm_top_inst.spi_top_inst.sck_meta
+ clknet_leaf_9_CLK _0197_ net160 VDD VSS sg13g2_dfrbpq_1
Xmain_fsm_top_inst.spi_top_inst.sck_sync$_SDFF_PP0_ main_fsm_top_inst.spi_top_inst.sck_sync
+ clknet_leaf_13_CLK _0140_ net161 VDD VSS sg13g2_dfrbpq_1
Xmain_fsm_top_inst.spi_top_inst.spi_reg.bit_cell0.data_out$_SDFFE_PP0P_
+ main_fsm_top_inst.spi_top_inst.spi_reg.bit_cell0.DATA_OUT
+ clknet_leaf_16_CLK _0228_ net162 VDD VSS sg13g2_dfrbpq_1
Xmain_fsm_top_inst.spi_top_inst.spi_reg.bit_cell0.value_out$_SDFFE_PP0P_
+ main_fsm_top_inst.spi_top_inst.spi_reg.bit_cell0.VALUE_OUT
+ clknet_leaf_16_CLK _0229_ net163 VDD VSS sg13g2_dfrbpq_1
Xmain_fsm_top_inst.spi_top_inst.spi_reg.bit_cell1.data_out$_SDFFE_PP0P_
+ main_fsm_top_inst.spi_top_inst.spi_reg.bit_cell1.DATA_OUT
+ clknet_leaf_18_CLK _0121_ net164 VDD VSS sg13g2_dfrbpq_1
Xmain_fsm_top_inst.spi_top_inst.spi_reg.bit_cell1.value_out$_SDFFE_PP0P_
+ main_fsm_top_inst.spi_top_inst.spi_reg.bit_cell1.VALUE_OUT
+ clknet_leaf_18_CLK _0227_ net165 VDD VSS sg13g2_dfrbpq_1
Xmain_fsm_top_inst.spi_top_inst.spi_reg.bit_cell2.data_out$_SDFFE_PP0P_
+ main_fsm_top_inst.spi_top_inst.spi_reg.bit_cell2.DATA_OUT
+ clknet_leaf_18_CLK _0078_ net166 VDD VSS sg13g2_dfrbpq_1
Xmain_fsm_top_inst.spi_top_inst.spi_reg.bit_cell2.value_out$_SDFFE_PP0P_
+ main_fsm_top_inst.spi_top_inst.spi_reg.bit_cell2.VALUE_OUT
+ clknet_leaf_17_CLK _0226_ net167 VDD VSS sg13g2_dfrbpq_1
Xmain_fsm_top_inst.spi_top_inst.spi_reg.bit_cell3.data_out$_SDFFE_PP0P_
+ main_fsm_top_inst.spi_top_inst.spi_reg.bit_cell3.DATA_OUT
+ clknet_leaf_18_CLK _0073_ net168 VDD VSS sg13g2_dfrbpq_1
Xmain_fsm_top_inst.spi_top_inst.spi_reg.bit_cell3.value_out$_SDFFE_PP0P_
+ main_fsm_top_inst.spi_top_inst.spi_reg.bit_cell3.VALUE_OUT
+ clknet_leaf_18_CLK _0074_ net169 VDD VSS sg13g2_dfrbpq_1
Xmain_fsm_top_inst.spi_top_inst.spi_reg.bit_cell4.data_out$_SDFFE_PP0P_
+ main_fsm_top_inst.spi_top_inst.spi_reg.bit_cell4.DATA_OUT
+ clknet_leaf_16_CLK _0068_ net170 VDD VSS sg13g2_dfrbpq_1
Xmain_fsm_top_inst.spi_top_inst.spi_reg.bit_cell4.value_out$_SDFFE_PP0P_
+ main_fsm_top_inst.spi_top_inst.spi_reg.bit_cell4.VALUE_OUT
+ clknet_leaf_19_CLK _0069_ net171 VDD VSS sg13g2_dfrbpq_1
Xmain_fsm_top_inst.spi_top_inst.spi_reg.bit_cell5.data_out$_SDFFE_PP0P_
+ main_fsm_top_inst.spi_top_inst.spi_reg.bit_cell5.DATA_OUT
+ clknet_leaf_16_CLK _0065_ net172 VDD VSS sg13g2_dfrbpq_1
Xmain_fsm_top_inst.spi_top_inst.spi_reg.bit_cell5.value_out$_SDFFE_PP0P_
+ main_fsm_top_inst.spi_top_inst.spi_reg.bit_cell5.VALUE_OUT
+ clknet_leaf_16_CLK _0066_ net173 VDD VSS sg13g2_dfrbpq_1
Xmain_fsm_top_inst.spi_top_inst.spi_reg.bit_cell6.data_out$_SDFFE_PP0P_
+ main_fsm_top_inst.spi_top_inst.spi_reg.bit_cell6.DATA_OUT
+ clknet_leaf_17_CLK _0061_ net174 VDD VSS sg13g2_dfrbpq_1
Xmain_fsm_top_inst.spi_top_inst.spi_reg.bit_cell6.value_out$_SDFFE_PP0P_
+ main_fsm_top_inst.spi_top_inst.spi_reg.bit_cell6.VALUE_OUT
+ clknet_leaf_17_CLK _0062_ net175 VDD VSS sg13g2_dfrbpq_1
Xmain_fsm_top_inst.spi_top_inst.spi_reg.bit_cell7.data_out$_SDFFE_PP0P_
+ main_fsm_top_inst.spi_top_inst.spi_reg.bit_cell7.DATA_OUT
+ clknet_leaf_17_CLK _0192_ net176 VDD VSS sg13g2_dfrbpq_1
Xmain_fsm_top_inst.spi_top_inst.spi_reg.bit_cell7.value_out$_SDFFE_PP0P_
+ main_fsm_top_inst.spi_top_inst.spi_reg.bit_cell7.VALUE_OUT
+ clknet_leaf_17_CLK _0060_ net177 VDD VSS sg13g2_dfrbpq_1
Xmain_fsm_top_inst.spi_tx.bypass_rg$_SDFF_PP1_ main_fsm_top_inst.spi_tx.bypass_rg
+ clknet_leaf_13_CLK _0120_ net178 VDD VSS sg13g2_dfrbpq_1
Xmain_fsm_top_inst.spi_tx.data_rg\[0\]$_SDFFE_PP0P_ main_fsm_top_inst.spi_tx.data_rg\[0\]
+ clknet_leaf_14_CLK _0188_ net179 VDD VSS sg13g2_dfrbpq_1
Xmain_fsm_top_inst.spi_tx.data_rg\[1\]$_SDFFE_PP0P_ main_fsm_top_inst.spi_tx.data_rg\[1\]
+ clknet_leaf_15_CLK _0187_ net180 VDD VSS sg13g2_dfrbpq_1
Xmain_fsm_top_inst.spi_tx.data_rg\[2\]$_SDFFE_PP0P_ main_fsm_top_inst.spi_tx.data_rg\[2\]
+ clknet_leaf_14_CLK _0186_ net181 VDD VSS sg13g2_dfrbpq_1
Xmain_fsm_top_inst.spi_tx.data_rg\[3\]$_SDFFE_PP0P_ main_fsm_top_inst.spi_tx.data_rg\[3\]
+ clknet_leaf_15_CLK _0185_ net182 VDD VSS sg13g2_dfrbpq_1
Xmain_fsm_top_inst.spi_tx.data_rg\[4\]$_SDFFE_PP0P_ main_fsm_top_inst.spi_tx.data_rg\[4\]
+ clknet_leaf_13_CLK _0184_ net183 VDD VSS sg13g2_dfrbpq_1
Xmain_fsm_top_inst.spi_tx.data_rg\[5\]$_SDFFE_PP0P_ main_fsm_top_inst.spi_tx.data_rg\[5\]
+ clknet_leaf_15_CLK _0183_ net184 VDD VSS sg13g2_dfrbpq_1
Xmain_fsm_top_inst.spi_tx.data_rg\[6\]$_SDFFE_PP0P_ main_fsm_top_inst.spi_tx.data_rg\[6\]
+ clknet_leaf_15_CLK _0182_ net185 VDD VSS sg13g2_dfrbpq_1
Xmain_fsm_top_inst.spi_tx.data_rg\[7\]$_SDFFE_PP0P_ main_fsm_top_inst.spi_tx.data_rg\[7\]
+ clknet_leaf_14_CLK _0143_ net186 VDD VSS sg13g2_dfrbpq_1
Xserializer_inst.fake_adc.sipo_flip_flops\[0\]$_SDFF_PP0_
+ serializer_inst.fake_adc.sipo_flip_flops\[0\] clknet_leaf_28_CLK
+ _0015_ net187 VDD VSS sg13g2_dfrbpq_1
Xserializer_inst.fake_adc.sipo_flip_flops\[1\]$_SDFF_PP0_
+ serializer_inst.fake_adc.sipo_flip_flops\[1\] clknet_leaf_28_CLK
+ _0014_ net188 VDD VSS sg13g2_dfrbpq_1
Xserializer_inst.fake_adc.sipo_flip_flops\[2\]$_SDFF_PP0_
+ serializer_inst.fake_adc.sipo_flip_flops\[2\] clknet_leaf_32_CLK
+ _0233_ net189 VDD VSS sg13g2_dfrbpq_1
Xserializer_inst.fake_adc.sipo_flip_flops\[3\]$_SDFF_PP0_
+ serializer_inst.fake_adc.sipo_flip_flops\[3\] clknet_leaf_32_CLK
+ _0223_ net190 VDD VSS sg13g2_dfrbpq_1
Xserializer_inst.fake_adc.sipo_flip_flops\[4\]$_SDFF_PP0_
+ serializer_inst.fake_adc.sipo_flip_flops\[4\] clknet_leaf_34_CLK
+ _0222_ net191 VDD VSS sg13g2_dfrbpq_1
Xserializer_inst.fake_adc.sipo_flip_flops\[5\]$_SDFF_PP0_
+ serializer_inst.fake_adc.sipo_flip_flops\[5\] clknet_leaf_34_CLK
+ _0221_ net192 VDD VSS sg13g2_dfrbpq_1
Xserializer_inst.fake_adc.sipo_flip_flops\[6\]$_SDFF_PP0_
+ serializer_inst.fake_adc.sipo_flip_flops\[6\] clknet_leaf_34_CLK
+ _0220_ net193 VDD VSS sg13g2_dfrbpq_1
Xserializer_inst.fake_adc.sipo_flip_flops\[7\]$_SDFF_PP0_
+ serializer_inst.fake_adc.sipo_flip_flops\[7\] clknet_leaf_33_CLK
+ _0219_ net194 VDD VSS sg13g2_dfrbpq_1
Xserializer_inst.fake_adc.sipo_flip_flops\[8\]$_SDFF_PP0_
+ serializer_inst.fake_adc.sipo_flip_flops\[8\] clknet_leaf_33_CLK
+ _0218_ net195 VDD VSS sg13g2_dfrbpq_1
Xserializer_inst.fake_adc.sipo_flip_flops\[9\]$_SDFF_PP0_
+ serializer_inst.fake_adc.sipo_flip_flops\[9\] clknet_leaf_32_CLK
+ _0147_ net196 VDD VSS sg13g2_dfrbpq_1
Xserializer_inst.fake_adc.skid.bypass_rg$_SDFF_PP1_ serializer_inst.fake_adc.skid.bypass_rg
+ clknet_leaf_28_CLK _0146_ net197 VDD VSS sg13g2_dfrbpq_1
Xserializer_inst.fake_adc.skid.data_rg\[0\]$_SDFFE_PP0P_ serializer_inst.fake_adc.skid.data_rg\[0\]
+ clknet_leaf_28_CLK _0214_ net198 VDD VSS sg13g2_dfrbpq_1
Xserializer_inst.fake_adc.skid.data_rg\[1\]$_SDFFE_PP0P_ serializer_inst.fake_adc.skid.data_rg\[1\]
+ clknet_leaf_28_CLK _0213_ net199 VDD VSS sg13g2_dfrbpq_1
Xserializer_inst.fake_adc.skid.data_rg\[2\]$_SDFFE_PP0P_ serializer_inst.fake_adc.skid.data_rg\[2\]
+ clknet_leaf_33_CLK _0212_ net200 VDD VSS sg13g2_dfrbpq_1
Xserializer_inst.fake_adc.skid.data_rg\[3\]$_SDFFE_PP0P_ serializer_inst.fake_adc.skid.data_rg\[3\]
+ clknet_leaf_34_CLK _0210_ net201 VDD VSS sg13g2_dfrbpq_1
Xserializer_inst.fake_adc.skid.data_rg\[4\]$_SDFFE_PP0P_ serializer_inst.fake_adc.skid.data_rg\[4\]
+ clknet_leaf_33_CLK _0209_ net202 VDD VSS sg13g2_dfrbpq_1
Xserializer_inst.fake_adc.skid.data_rg\[5\]$_SDFFE_PP0P_ serializer_inst.fake_adc.skid.data_rg\[5\]
+ clknet_leaf_34_CLK _0208_ net203 VDD VSS sg13g2_dfrbpq_1
Xserializer_inst.fake_adc.skid.data_rg\[6\]$_SDFFE_PP0P_ serializer_inst.fake_adc.skid.data_rg\[6\]
+ clknet_leaf_35_CLK _0207_ net204 VDD VSS sg13g2_dfrbpq_1
Xserializer_inst.fake_adc.skid.data_rg\[7\]$_SDFFE_PP0P_ serializer_inst.fake_adc.skid.data_rg\[7\]
+ clknet_leaf_33_CLK _0206_ net205 VDD VSS sg13g2_dfrbpq_1
Xserializer_inst.fake_adc.skid.data_rg\[8\]$_SDFFE_PP0P_ serializer_inst.fake_adc.skid.data_rg\[8\]
+ clknet_leaf_32_CLK _0205_ net206 VDD VSS sg13g2_dfrbpq_1
Xserializer_inst.fake_adc.skid.data_rg\[9\]$_SDFFE_PP0P_ serializer_inst.fake_adc.skid.data_rg\[9\]
+ clknet_leaf_32_CLK _0196_ net207 VDD VSS sg13g2_dfrbpq_1
Xserializer_inst.fake_adc.skid.ready_in$_DFF_P_ adc_ready_out_sig
+ clknet_leaf_26_CLK _0003_ net208 VDD VSS sg13g2_dfrbpq_1
Xserializer_inst.freeze_delay$_SDFF_PP1_ serializer_inst.freeze_delay
+ clknet_leaf_23_CLK _0191_ net209 VDD VSS sg13g2_dfrbpq_1
Xserializer_inst.piso.DATA_IN\[16\]$_SDFF_PP0_ afe_controller_inst.AFE_CRTL_OUTPUTS\[6\]
+ clknet_leaf_26_CLK _0225_ net210 VDD VSS sg13g2_dfrbpq_1
Xserializer_inst.piso.DATA_IN\[17\]$_DFF_P_ afe_controller_inst.AFE_CRTL_OUTPUTS\[7\]
+ clknet_leaf_27_CLK _0002_ net211 VDD VSS sg13g2_dfrbpq_1
Xserializer_inst.piso.DATA_IN\[18\]$_DFF_P_ afe_controller_inst.AFE_CRTL_OUTPUTS\[8\]
+ clknet_leaf_26_CLK _0001_ net212 VDD VSS sg13g2_dfrbpq_1
Xserializer_inst.piso.DATA_IN\[19\]$_DFF_P_ afe_controller_inst.AFE_CRTL_OUTPUTS\[9\]
+ clknet_leaf_27_CLK _0000_ net213 VDD VSS sg13g2_dfrbpq_1
Xserializer_inst.piso.piso_flip_flops\[0\]$_SDFF_PP0_ serializer_inst.piso.piso_flip_flops\[0\]
+ clknet_leaf_23_CLK _0232_ net214 VDD VSS sg13g2_dfrbpq_1
Xserializer_inst.piso.piso_flip_flops\[10\]$_SDFF_PP0_ serializer_inst.piso.piso_flip_flops\[10\]
+ clknet_leaf_24_CLK _0028_ net215 VDD VSS sg13g2_dfrbpq_1
Xserializer_inst.piso.piso_flip_flops\[11\]$_SDFF_PP0_ serializer_inst.piso.piso_flip_flops\[11\]
+ clknet_leaf_25_CLK _0027_ net216 VDD VSS sg13g2_dfrbpq_1
Xserializer_inst.piso.piso_flip_flops\[12\]$_SDFF_PP0_ serializer_inst.piso.piso_flip_flops\[12\]
+ clknet_leaf_25_CLK _0026_ net217 VDD VSS sg13g2_dfrbpq_1
Xserializer_inst.piso.piso_flip_flops\[13\]$_SDFF_PP0_ serializer_inst.piso.piso_flip_flops\[13\]
+ clknet_leaf_25_CLK _0025_ net218 VDD VSS sg13g2_dfrbpq_1
Xserializer_inst.piso.piso_flip_flops\[14\]$_SDFF_PP0_ serializer_inst.piso.piso_flip_flops\[14\]
+ clknet_leaf_25_CLK _0024_ net219 VDD VSS sg13g2_dfrbpq_1
Xserializer_inst.piso.piso_flip_flops\[15\]$_SDFF_PP0_ serializer_inst.piso.piso_flip_flops\[15\]
+ clknet_leaf_26_CLK _0023_ net220 VDD VSS sg13g2_dfrbpq_1
Xserializer_inst.piso.piso_flip_flops\[16\]$_SDFF_PP0_ serializer_inst.piso.piso_flip_flops\[16\]
+ clknet_leaf_26_CLK _0022_ net221 VDD VSS sg13g2_dfrbpq_1
Xserializer_inst.piso.piso_flip_flops\[17\]$_SDFF_PP0_ serializer_inst.piso.piso_flip_flops\[17\]
+ clknet_leaf_25_CLK _0021_ net222 VDD VSS sg13g2_dfrbpq_1
Xserializer_inst.piso.piso_flip_flops\[18\]$_SDFF_PP0_ serializer_inst.piso.piso_flip_flops\[18\]
+ clknet_leaf_25_CLK _0020_ net223 VDD VSS sg13g2_dfrbpq_1
Xserializer_inst.piso.piso_flip_flops\[19\]$_SDFF_PP0_ serializer_inst.piso.piso_flip_flops\[19\]
+ clknet_leaf_25_CLK _0019_ net224 VDD VSS sg13g2_dfrbpq_1
Xserializer_inst.piso.piso_flip_flops\[1\]$_SDFF_PP0_ serializer_inst.piso.piso_flip_flops\[1\]
+ clknet_leaf_23_CLK _0036_ net225 VDD VSS sg13g2_dfrbpq_1
Xserializer_inst.piso.piso_flip_flops\[20\]$_SDFF_PP0_ serializer_inst.piso.piso_flip_flops\[20\]
+ clknet_leaf_24_CLK _0018_ net226 VDD VSS sg13g2_dfrbpq_1
Xserializer_inst.piso.piso_flip_flops\[21\]$_SDFF_PP0_ net246
+ clknet_leaf_19_CLK _0236_ net227 VDD VSS sg13g2_dfrbpq_1
Xserializer_inst.piso.piso_flip_flops\[2\]$_SDFF_PP0_ serializer_inst.piso.piso_flip_flops\[2\]
+ clknet_leaf_24_CLK _0035_ net228 VDD VSS sg13g2_dfrbpq_1
Xserializer_inst.piso.piso_flip_flops\[3\]$_SDFF_PP0_ serializer_inst.piso.piso_flip_flops\[3\]
+ clknet_leaf_24_CLK _0034_ net229 VDD VSS sg13g2_dfrbpq_1
Xserializer_inst.piso.piso_flip_flops\[4\]$_SDFF_PP0_ serializer_inst.piso.piso_flip_flops\[4\]
+ clknet_leaf_24_CLK _0033_ net230 VDD VSS sg13g2_dfrbpq_1
Xserializer_inst.piso.piso_flip_flops\[5\]$_SDFF_PP0_ serializer_inst.piso.piso_flip_flops\[5\]
+ clknet_leaf_24_CLK _0231_ net231 VDD VSS sg13g2_dfrbpq_1
Xserializer_inst.piso.piso_flip_flops\[6\]$_SDFF_PP0_ serializer_inst.piso.piso_flip_flops\[6\]
+ clknet_leaf_23_CLK _0032_ net232 VDD VSS sg13g2_dfrbpq_1
Xserializer_inst.piso.piso_flip_flops\[7\]$_SDFF_PP0_ serializer_inst.piso.piso_flip_flops\[7\]
+ clknet_leaf_23_CLK _0031_ net233 VDD VSS sg13g2_dfrbpq_1
Xserializer_inst.piso.piso_flip_flops\[8\]$_SDFF_PP0_ serializer_inst.piso.piso_flip_flops\[8\]
+ clknet_leaf_24_CLK _0030_ net234 VDD VSS sg13g2_dfrbpq_1
Xserializer_inst.piso.piso_flip_flops\[9\]$_SDFF_PP0_ serializer_inst.piso.piso_flip_flops\[9\]
+ clknet_leaf_24_CLK _0029_ net235 VDD VSS sg13g2_dfrbpq_1
Xserializer_inst.scan_out_driver.scan_valid$_SDFFE_PP0P_ net247
+ clknet_leaf_20_CLK _0013_ net236 VDD VSS sg13g2_dfrbpq_1
X_2129__1 net VDD VSS sg13g2_tiehi
X_2130__2 net1 VDD VSS sg13g2_tiehi
X_2131__3 net2 VDD VSS sg13g2_tiehi
X_2132__4 net3 VDD VSS sg13g2_tiehi
X_2133__5 net4 VDD VSS sg13g2_tiehi
Xafe_controller_inst.clear$_SDFF_PP0__6 net5 VDD VSS sg13g2_tiehi
Xafe_controller_inst.fifo.WE$_DFF_P__7 net6 VDD VSS sg13g2_tiehi
Xafe_controller_inst.fifo.mem\[0\]\[0\]$_SDFFCE_PN0P__8 net7
+ VDD VSS sg13g2_tiehi
Xafe_controller_inst.fifo.mem\[0\]\[1\]$_SDFFCE_PN0P__9 net8
+ VDD VSS sg13g2_tiehi
Xafe_controller_inst.fifo.mem\[0\]\[2\]$_SDFFCE_PN0P__10 net9
+ VDD VSS sg13g2_tiehi
Xafe_controller_inst.fifo.mem\[0\]\[3\]$_SDFFCE_PN0P__11 net10
+ VDD VSS sg13g2_tiehi
Xafe_controller_inst.fifo.mem\[0\]\[4\]$_SDFFCE_PN0P__12 net11
+ VDD VSS sg13g2_tiehi
Xafe_controller_inst.fifo.mem\[0\]\[5\]$_SDFFCE_PN0P__13 net12
+ VDD VSS sg13g2_tiehi
Xafe_controller_inst.fifo.mem\[0\]\[6\]$_SDFFCE_PN0P__14 net13
+ VDD VSS sg13g2_tiehi
Xafe_controller_inst.fifo.mem\[0\]\[7\]$_SDFFCE_PN0P__15 net14
+ VDD VSS sg13g2_tiehi
Xafe_controller_inst.fifo.mem\[1\]\[0\]$_SDFFCE_PN0P__16 net15
+ VDD VSS sg13g2_tiehi
Xafe_controller_inst.fifo.mem\[1\]\[1\]$_SDFFCE_PN0P__17 net16
+ VDD VSS sg13g2_tiehi
Xafe_controller_inst.fifo.mem\[1\]\[2\]$_SDFFCE_PN0P__18 net17
+ VDD VSS sg13g2_tiehi
Xafe_controller_inst.fifo.mem\[1\]\[3\]$_SDFFCE_PN0P__19 net18
+ VDD VSS sg13g2_tiehi
Xafe_controller_inst.fifo.mem\[1\]\[4\]$_SDFFCE_PN0P__20 net19
+ VDD VSS sg13g2_tiehi
Xafe_controller_inst.fifo.mem\[1\]\[5\]$_SDFFCE_PN0P__21 net20
+ VDD VSS sg13g2_tiehi
Xafe_controller_inst.fifo.mem\[1\]\[6\]$_SDFFCE_PN0P__22 net21
+ VDD VSS sg13g2_tiehi
Xafe_controller_inst.fifo.mem\[1\]\[7\]$_SDFFCE_PN0P__23 net22
+ VDD VSS sg13g2_tiehi
Xafe_controller_inst.fifo.mem\[2\]\[0\]$_SDFFCE_PN0P__24 net23
+ VDD VSS sg13g2_tiehi
Xafe_controller_inst.fifo.mem\[2\]\[1\]$_SDFFCE_PN0P__25 net24
+ VDD VSS sg13g2_tiehi
Xafe_controller_inst.fifo.mem\[2\]\[2\]$_SDFFCE_PN0P__26 net25
+ VDD VSS sg13g2_tiehi
Xafe_controller_inst.fifo.mem\[2\]\[3\]$_SDFFCE_PN0P__27 net26
+ VDD VSS sg13g2_tiehi
Xafe_controller_inst.fifo.mem\[2\]\[4\]$_SDFFCE_PN0P__28 net27
+ VDD VSS sg13g2_tiehi
Xafe_controller_inst.fifo.mem\[2\]\[5\]$_SDFFCE_PN0P__29 net28
+ VDD VSS sg13g2_tiehi
Xafe_controller_inst.fifo.mem\[2\]\[6\]$_SDFFCE_PN0P__30 net29
+ VDD VSS sg13g2_tiehi
Xafe_controller_inst.fifo.mem\[2\]\[7\]$_SDFFCE_PN0P__31 net30
+ VDD VSS sg13g2_tiehi
Xafe_controller_inst.fifo.mem\[3\]\[0\]$_SDFFCE_PN0P__32 net31
+ VDD VSS sg13g2_tiehi
Xafe_controller_inst.fifo.mem\[3\]\[1\]$_SDFFCE_PN0P__33 net32
+ VDD VSS sg13g2_tiehi
Xafe_controller_inst.fifo.mem\[3\]\[2\]$_SDFFCE_PN0P__34 net33
+ VDD VSS sg13g2_tiehi
Xafe_controller_inst.fifo.mem\[3\]\[3\]$_SDFFCE_PN0P__35 net34
+ VDD VSS sg13g2_tiehi
Xafe_controller_inst.fifo.mem\[3\]\[4\]$_SDFFCE_PN0P__36 net35
+ VDD VSS sg13g2_tiehi
Xafe_controller_inst.fifo.mem\[3\]\[5\]$_SDFFCE_PN0P__37 net36
+ VDD VSS sg13g2_tiehi
Xafe_controller_inst.fifo.mem\[3\]\[6\]$_SDFFCE_PN0P__38 net37
+ VDD VSS sg13g2_tiehi
Xafe_controller_inst.fifo.mem\[3\]\[7\]$_SDFFCE_PN0P__39 net38
+ VDD VSS sg13g2_tiehi
Xafe_controller_inst.fifo.r_ptr\[0\]$_SDFFE_PP0P__40 net39
+ VDD VSS sg13g2_tiehi
Xafe_controller_inst.fifo.r_ptr\[1\]$_SDFFE_PP0P__41 net40
+ VDD VSS sg13g2_tiehi
Xafe_controller_inst.fifo.r_ptr\[2\]$_SDFFE_PP0P__42 net41
+ VDD VSS sg13g2_tiehi
Xafe_controller_inst.fifo.w_ptr\[0\]$_SDFFE_PP0P__43 net42
+ VDD VSS sg13g2_tiehi
Xafe_controller_inst.fifo.w_ptr\[1\]$_SDFFE_PP0P__44 net43
+ VDD VSS sg13g2_tiehi
Xafe_controller_inst.fifo.w_ptr\[2\]$_SDFFE_PP0P__45 net44
+ VDD VSS sg13g2_tiehi
Xafe_controller_inst.fifo_in_sel\[0\]$_DFF_P__46 net45 VDD
+ VSS sg13g2_tiehi
Xafe_controller_inst.fifo_in_sel\[1\]$_DFF_P__47 net46 VDD
+ VSS sg13g2_tiehi
Xafe_controller_inst.fsm.state\[0\]$_SDFFE_PP0P__48 net47
+ VDD VSS sg13g2_tiehi
Xafe_controller_inst.fsm.state\[1\]$_SDFFE_PP0P__49 net48
+ VDD VSS sg13g2_tiehi
Xafe_controller_inst.fsm.state\[2\]$_SDFFE_PP0P__50 net49
+ VDD VSS sg13g2_tiehi
Xafe_controller_inst.fsm.state\[3\]$_SDFFE_PP0P__51 net50
+ VDD VSS sg13g2_tiehi
Xafe_controller_inst.fsm.state\[4\]$_SDFFE_PP0P__52 net51
+ VDD VSS sg13g2_tiehi
Xafe_controller_inst.valid_control.state$_SDFFE_PP0P__53 net52
+ VDD VSS sg13g2_tiehi
Xmain_fsm_top_inst.Register_File_inst.registers\[0\]\[0\]$_SDFFCE_PN1P__54
+ net53 VDD VSS sg13g2_tiehi
Xmain_fsm_top_inst.Register_File_inst.registers\[0\]\[1\]$_SDFFCE_PN1P__55
+ net54 VDD VSS sg13g2_tiehi
Xmain_fsm_top_inst.Register_File_inst.registers\[0\]\[2\]$_SDFFCE_PN1P__56
+ net55 VDD VSS sg13g2_tiehi
Xmain_fsm_top_inst.Register_File_inst.registers\[0\]\[3\]$_SDFFCE_PN0P__57
+ net56 VDD VSS sg13g2_tiehi
Xmain_fsm_top_inst.Register_File_inst.registers\[0\]\[4\]$_SDFFCE_PN1P__58
+ net57 VDD VSS sg13g2_tiehi
Xmain_fsm_top_inst.Register_File_inst.registers\[0\]\[5\]$_SDFFCE_PN0P__59
+ net58 VDD VSS sg13g2_tiehi
Xmain_fsm_top_inst.Register_File_inst.registers\[0\]\[6\]$_SDFFCE_PN1P__60
+ net59 VDD VSS sg13g2_tiehi
Xmain_fsm_top_inst.Register_File_inst.registers\[0\]\[7\]$_SDFFCE_PN1P__61
+ net60 VDD VSS sg13g2_tiehi
Xmain_fsm_top_inst.Register_File_inst.registers\[1\]\[0\]$_SDFFCE_PN0P__62
+ net61 VDD VSS sg13g2_tiehi
Xmain_fsm_top_inst.Register_File_inst.registers\[1\]\[1\]$_SDFFCE_PN0P__63
+ net62 VDD VSS sg13g2_tiehi
Xmain_fsm_top_inst.Register_File_inst.registers\[1\]\[2\]$_SDFFCE_PN0P__64
+ net63 VDD VSS sg13g2_tiehi
Xmain_fsm_top_inst.Register_File_inst.registers\[1\]\[3\]$_SDFFCE_PN0P__65
+ net64 VDD VSS sg13g2_tiehi
Xmain_fsm_top_inst.Register_File_inst.registers\[1\]\[4\]$_SDFFCE_PN0P__66
+ net65 VDD VSS sg13g2_tiehi
Xmain_fsm_top_inst.Register_File_inst.registers\[1\]\[5\]$_SDFFCE_PN0P__67
+ net66 VDD VSS sg13g2_tiehi
Xmain_fsm_top_inst.Register_File_inst.registers\[1\]\[6\]$_SDFFCE_PN0P__68
+ net67 VDD VSS sg13g2_tiehi
Xmain_fsm_top_inst.Register_File_inst.registers\[1\]\[7\]$_SDFFCE_PN0P__69
+ net68 VDD VSS sg13g2_tiehi
Xmain_fsm_top_inst.Register_File_inst.registers\[2\]\[0\]$_SDFFCE_PN0P__70
+ net69 VDD VSS sg13g2_tiehi
Xmain_fsm_top_inst.Register_File_inst.registers\[2\]\[1\]$_SDFFCE_PN0P__71
+ net70 VDD VSS sg13g2_tiehi
Xmain_fsm_top_inst.Register_File_inst.registers\[2\]\[2\]$_SDFFCE_PN0P__72
+ net71 VDD VSS sg13g2_tiehi
Xmain_fsm_top_inst.Register_File_inst.registers\[2\]\[3\]$_SDFFCE_PN0P__73
+ net72 VDD VSS sg13g2_tiehi
Xmain_fsm_top_inst.Register_File_inst.registers\[2\]\[4\]$_SDFFCE_PN0P__74
+ net73 VDD VSS sg13g2_tiehi
Xmain_fsm_top_inst.Register_File_inst.registers\[2\]\[5\]$_SDFFCE_PN0P__75
+ net74 VDD VSS sg13g2_tiehi
Xmain_fsm_top_inst.Register_File_inst.registers\[2\]\[6\]$_SDFFCE_PN0P__76
+ net75 VDD VSS sg13g2_tiehi
Xmain_fsm_top_inst.Register_File_inst.registers\[2\]\[7\]$_SDFFCE_PN0P__77
+ net76 VDD VSS sg13g2_tiehi
Xmain_fsm_top_inst.Register_File_inst.registers\[3\]\[0\]$_SDFFCE_PN0P__78
+ net77 VDD VSS sg13g2_tiehi
Xmain_fsm_top_inst.Register_File_inst.registers\[3\]\[1\]$_SDFFCE_PN0P__79
+ net78 VDD VSS sg13g2_tiehi
Xmain_fsm_top_inst.Register_File_inst.registers\[3\]\[2\]$_SDFFCE_PN0P__80
+ net79 VDD VSS sg13g2_tiehi
Xmain_fsm_top_inst.Register_File_inst.registers\[3\]\[3\]$_SDFFCE_PN0P__81
+ net80 VDD VSS sg13g2_tiehi
Xmain_fsm_top_inst.Register_File_inst.registers\[3\]\[4\]$_SDFFCE_PN0P__82
+ net81 VDD VSS sg13g2_tiehi
Xmain_fsm_top_inst.Register_File_inst.registers\[3\]\[5\]$_SDFFCE_PN0P__83
+ net82 VDD VSS sg13g2_tiehi
Xmain_fsm_top_inst.Register_File_inst.registers\[3\]\[6\]$_SDFFCE_PN0P__84
+ net83 VDD VSS sg13g2_tiehi
Xmain_fsm_top_inst.Register_File_inst.registers\[3\]\[7\]$_SDFFCE_PN0P__85
+ net84 VDD VSS sg13g2_tiehi
Xmain_fsm_top_inst.Register_File_inst.registers\[4\]\[0\]$_SDFFCE_PN0P__86
+ net85 VDD VSS sg13g2_tiehi
Xmain_fsm_top_inst.Register_File_inst.registers\[4\]\[1\]$_SDFFCE_PN0P__87
+ net86 VDD VSS sg13g2_tiehi
Xmain_fsm_top_inst.Register_File_inst.registers\[4\]\[2\]$_SDFFCE_PN0P__88
+ net87 VDD VSS sg13g2_tiehi
Xmain_fsm_top_inst.Register_File_inst.registers\[4\]\[3\]$_SDFFCE_PN0P__89
+ net88 VDD VSS sg13g2_tiehi
Xmain_fsm_top_inst.Register_File_inst.registers\[4\]\[4\]$_SDFFCE_PN0P__90
+ net89 VDD VSS sg13g2_tiehi
Xmain_fsm_top_inst.Register_File_inst.registers\[4\]\[5\]$_SDFFCE_PN0P__91
+ net90 VDD VSS sg13g2_tiehi
Xmain_fsm_top_inst.Register_File_inst.registers\[4\]\[6\]$_SDFFCE_PN0P__92
+ net91 VDD VSS sg13g2_tiehi
Xmain_fsm_top_inst.Register_File_inst.registers\[4\]\[7\]$_SDFFCE_PN0P__93
+ net92 VDD VSS sg13g2_tiehi
Xmain_fsm_top_inst.Register_File_inst.registers\[5\]\[0\]$_SDFFCE_PN0P__94
+ net93 VDD VSS sg13g2_tiehi
Xmain_fsm_top_inst.Register_File_inst.registers\[5\]\[1\]$_SDFFCE_PN0P__95
+ net94 VDD VSS sg13g2_tiehi
Xmain_fsm_top_inst.Register_File_inst.registers\[5\]\[2\]$_SDFFCE_PN0P__96
+ net95 VDD VSS sg13g2_tiehi
Xmain_fsm_top_inst.Register_File_inst.registers\[5\]\[3\]$_SDFFCE_PN0P__97
+ net96 VDD VSS sg13g2_tiehi
Xmain_fsm_top_inst.Register_File_inst.registers\[5\]\[4\]$_SDFFCE_PN0P__98
+ net97 VDD VSS sg13g2_tiehi
Xmain_fsm_top_inst.Register_File_inst.registers\[5\]\[5\]$_SDFFCE_PN0P__99
+ net98 VDD VSS sg13g2_tiehi
Xmain_fsm_top_inst.Register_File_inst.registers\[5\]\[6\]$_SDFFCE_PN0P__100
+ net99 VDD VSS sg13g2_tiehi
Xmain_fsm_top_inst.Register_File_inst.registers\[5\]\[7\]$_SDFFCE_PN0P__101
+ net100 VDD VSS sg13g2_tiehi
Xmain_fsm_top_inst.Register_File_inst.registers\[6\]\[0\]$_SDFFCE_PN0P__102
+ net101 VDD VSS sg13g2_tiehi
Xmain_fsm_top_inst.Register_File_inst.registers\[6\]\[1\]$_SDFFCE_PN0P__103
+ net102 VDD VSS sg13g2_tiehi
Xmain_fsm_top_inst.Register_File_inst.registers\[6\]\[2\]$_SDFFCE_PN0P__104
+ net103 VDD VSS sg13g2_tiehi
Xmain_fsm_top_inst.Register_File_inst.registers\[6\]\[3\]$_SDFFCE_PN0P__105
+ net104 VDD VSS sg13g2_tiehi
Xmain_fsm_top_inst.Register_File_inst.registers\[6\]\[4\]$_SDFFCE_PN0P__106
+ net105 VDD VSS sg13g2_tiehi
Xmain_fsm_top_inst.Register_File_inst.registers\[6\]\[5\]$_SDFFCE_PN0P__107
+ net106 VDD VSS sg13g2_tiehi
Xmain_fsm_top_inst.Register_File_inst.registers\[6\]\[6\]$_SDFFCE_PN0P__108
+ net107 VDD VSS sg13g2_tiehi
Xmain_fsm_top_inst.Register_File_inst.registers\[6\]\[7\]$_SDFFCE_PN0P__109
+ net108 VDD VSS sg13g2_tiehi
Xmain_fsm_top_inst.Register_File_inst.registers\[7\]\[0\]$_SDFFCE_PN0P__110
+ net109 VDD VSS sg13g2_tiehi
Xmain_fsm_top_inst.Register_File_inst.registers\[7\]\[1\]$_SDFFCE_PN0P__111
+ net110 VDD VSS sg13g2_tiehi
Xmain_fsm_top_inst.Register_File_inst.registers\[7\]\[2\]$_SDFFCE_PN0P__112
+ net111 VDD VSS sg13g2_tiehi
Xmain_fsm_top_inst.Register_File_inst.registers\[7\]\[3\]$_SDFFCE_PN0P__113
+ net112 VDD VSS sg13g2_tiehi
Xmain_fsm_top_inst.Register_File_inst.registers\[7\]\[4\]$_SDFFCE_PN0P__114
+ net113 VDD VSS sg13g2_tiehi
Xmain_fsm_top_inst.Register_File_inst.registers\[7\]\[5\]$_SDFFCE_PN0P__115
+ net114 VDD VSS sg13g2_tiehi
Xmain_fsm_top_inst.Register_File_inst.registers\[7\]\[6\]$_SDFFCE_PN0P__116
+ net115 VDD VSS sg13g2_tiehi
Xmain_fsm_top_inst.Register_File_inst.registers\[7\]\[7\]$_SDFFCE_PN0P__117
+ net116 VDD VSS sg13g2_tiehi
Xmain_fsm_top_inst.cfg_register_inst.data\[0\]$_SDFFE_PP0P__118
+ net117 VDD VSS sg13g2_tiehi
Xmain_fsm_top_inst.cfg_register_inst.data\[1\]$_SDFFE_PP0P__119
+ net118 VDD VSS sg13g2_tiehi
Xmain_fsm_top_inst.cfg_register_inst.data\[2\]$_SDFFE_PP0P__120
+ net119 VDD VSS sg13g2_tiehi
Xmain_fsm_top_inst.cfg_register_inst.data\[3\]$_SDFFE_PP0P__121
+ net120 VDD VSS sg13g2_tiehi
Xmain_fsm_top_inst.cfg_register_inst.data\[4\]$_SDFFE_PP0P__122
+ net121 VDD VSS sg13g2_tiehi
Xmain_fsm_top_inst.main_fsm_inst.current_state\[0\]$_SDFFE_PP1P__123
+ net122 VDD VSS sg13g2_tiehi
Xmain_fsm_top_inst.main_fsm_inst.current_state\[1\]$_SDFFE_PP0P__124
+ net123 VDD VSS sg13g2_tiehi
Xmain_fsm_top_inst.main_fsm_inst.current_state\[2\]$_SDFFE_PP1P__125
+ net124 VDD VSS sg13g2_tiehi
Xmain_fsm_top_inst.main_fsm_inst.current_state\[3\]$_SDFFE_PP1P__126
+ net125 VDD VSS sg13g2_tiehi
Xmain_fsm_top_inst.main_fsm_inst.fsm_data_rdy_flag$_SDFFE_PP0P__127
+ net126 VDD VSS sg13g2_tiehi
Xmain_fsm_top_inst.pointer_register_inst.data_out\[0\]$_SDFFE_PP0N__128
+ net127 VDD VSS sg13g2_tiehi
Xmain_fsm_top_inst.pointer_register_inst.data_out\[1\]$_SDFFE_PP0N__129
+ net128 VDD VSS sg13g2_tiehi
Xmain_fsm_top_inst.pointer_register_inst.data_out\[2\]$_SDFFE_PP0N__130
+ net129 VDD VSS sg13g2_tiehi
Xmain_fsm_top_inst.spi_rx.bypass_rg$_SDFF_PP1__131 net130
+ VDD VSS sg13g2_tiehi
Xmain_fsm_top_inst.spi_rx.data_rg\[0\]$_SDFFE_PP0P__132 net131
+ VDD VSS sg13g2_tiehi
Xmain_fsm_top_inst.spi_rx.data_rg\[1\]$_SDFFE_PP0P__133 net132
+ VDD VSS sg13g2_tiehi
Xmain_fsm_top_inst.spi_rx.data_rg\[2\]$_SDFFE_PP0P__134 net133
+ VDD VSS sg13g2_tiehi
Xmain_fsm_top_inst.spi_rx.data_rg\[3\]$_SDFFE_PP0P__135 net134
+ VDD VSS sg13g2_tiehi
Xmain_fsm_top_inst.spi_rx.data_rg\[4\]$_SDFFE_PP0P__136 net135
+ VDD VSS sg13g2_tiehi
Xmain_fsm_top_inst.spi_rx.data_rg\[5\]$_SDFFE_PP0P__137 net136
+ VDD VSS sg13g2_tiehi
Xmain_fsm_top_inst.spi_rx.data_rg\[6\]$_SDFFE_PP0P__138 net137
+ VDD VSS sg13g2_tiehi
Xmain_fsm_top_inst.spi_rx.data_rg\[7\]$_SDFFE_PP0P__139 net138
+ VDD VSS sg13g2_tiehi
Xmain_fsm_top_inst.spi_top_inst.counter_module.counter\[0\]$_SDFFE_PP0P__140
+ net139 VDD VSS sg13g2_tiehi
Xmain_fsm_top_inst.spi_top_inst.counter_module.counter\[1\]$_SDFFE_PP0P__141
+ net140 VDD VSS sg13g2_tiehi
Xmain_fsm_top_inst.spi_top_inst.counter_module.counter\[2\]$_SDFFE_PP0P__142
+ net141 VDD VSS sg13g2_tiehi
Xmain_fsm_top_inst.spi_top_inst.counter_module.counter\[3\]$_SDFFE_PP0P__143
+ net142 VDD VSS sg13g2_tiehi
Xmain_fsm_top_inst.spi_top_inst.cs_meta$_SDFF_PP0__144 net143
+ VDD VSS sg13g2_tiehi
Xmain_fsm_top_inst.spi_top_inst.cs_sync$_SDFF_PP0__145 net144
+ VDD VSS sg13g2_tiehi
Xmain_fsm_top_inst.spi_top_inst.edge_dummy$_SDFF_PP0__146
+ net145 VDD VSS sg13g2_tiehi
Xmain_fsm_top_inst.spi_top_inst.fsm.downstream_state\[0\]$_SDFFE_PP0P__147
+ net146 VDD VSS sg13g2_tiehi
Xmain_fsm_top_inst.spi_top_inst.fsm.downstream_state\[1\]$_SDFFE_PP0P__148
+ net147 VDD VSS sg13g2_tiehi
Xmain_fsm_top_inst.spi_top_inst.fsm.upstream_state\[0\]$_SDFFE_PP0P__149
+ net148 VDD VSS sg13g2_tiehi
Xmain_fsm_top_inst.spi_top_inst.fsm.upstream_state\[1\]$_SDFFE_PP0P__150
+ net149 VDD VSS sg13g2_tiehi
Xmain_fsm_top_inst.spi_top_inst.load_in\[0\]$_SDFFE_PP0P__151
+ net150 VDD VSS sg13g2_tiehi
Xmain_fsm_top_inst.spi_top_inst.load_in\[1\]$_SDFFE_PP0P__152
+ net151 VDD VSS sg13g2_tiehi
Xmain_fsm_top_inst.spi_top_inst.load_in\[2\]$_SDFFE_PP0P__153
+ net152 VDD VSS sg13g2_tiehi
Xmain_fsm_top_inst.spi_top_inst.load_in\[3\]$_SDFFE_PP0P__154
+ net153 VDD VSS sg13g2_tiehi
Xmain_fsm_top_inst.spi_top_inst.load_in\[4\]$_SDFFE_PP0P__155
+ net154 VDD VSS sg13g2_tiehi
Xmain_fsm_top_inst.spi_top_inst.load_in\[5\]$_SDFFE_PP0P__156
+ net155 VDD VSS sg13g2_tiehi
Xmain_fsm_top_inst.spi_top_inst.load_in\[6\]$_SDFFE_PP0P__157
+ net156 VDD VSS sg13g2_tiehi
Xmain_fsm_top_inst.spi_top_inst.load_in\[7\]$_SDFFE_PP0P__158
+ net157 VDD VSS sg13g2_tiehi
Xmain_fsm_top_inst.spi_top_inst.mosi_meta$_SDFF_PP0__159 net158
+ VDD VSS sg13g2_tiehi
Xmain_fsm_top_inst.spi_top_inst.mosi_sync$_SDFF_PP0__160 net159
+ VDD VSS sg13g2_tiehi
Xmain_fsm_top_inst.spi_top_inst.sck_meta$_SDFF_PP0__161 net160
+ VDD VSS sg13g2_tiehi
Xmain_fsm_top_inst.spi_top_inst.sck_sync$_SDFF_PP0__162 net161
+ VDD VSS sg13g2_tiehi
Xmain_fsm_top_inst.spi_top_inst.spi_reg.bit_cell0.data_out$_SDFFE_PP0P__163
+ net162 VDD VSS sg13g2_tiehi
Xmain_fsm_top_inst.spi_top_inst.spi_reg.bit_cell0.value_out$_SDFFE_PP0P__164
+ net163 VDD VSS sg13g2_tiehi
Xmain_fsm_top_inst.spi_top_inst.spi_reg.bit_cell1.data_out$_SDFFE_PP0P__165
+ net164 VDD VSS sg13g2_tiehi
Xmain_fsm_top_inst.spi_top_inst.spi_reg.bit_cell1.value_out$_SDFFE_PP0P__166
+ net165 VDD VSS sg13g2_tiehi
Xmain_fsm_top_inst.spi_top_inst.spi_reg.bit_cell2.data_out$_SDFFE_PP0P__167
+ net166 VDD VSS sg13g2_tiehi
Xmain_fsm_top_inst.spi_top_inst.spi_reg.bit_cell2.value_out$_SDFFE_PP0P__168
+ net167 VDD VSS sg13g2_tiehi
Xmain_fsm_top_inst.spi_top_inst.spi_reg.bit_cell3.data_out$_SDFFE_PP0P__169
+ net168 VDD VSS sg13g2_tiehi
Xmain_fsm_top_inst.spi_top_inst.spi_reg.bit_cell3.value_out$_SDFFE_PP0P__170
+ net169 VDD VSS sg13g2_tiehi
Xmain_fsm_top_inst.spi_top_inst.spi_reg.bit_cell4.data_out$_SDFFE_PP0P__171
+ net170 VDD VSS sg13g2_tiehi
Xmain_fsm_top_inst.spi_top_inst.spi_reg.bit_cell4.value_out$_SDFFE_PP0P__172
+ net171 VDD VSS sg13g2_tiehi
Xmain_fsm_top_inst.spi_top_inst.spi_reg.bit_cell5.data_out$_SDFFE_PP0P__173
+ net172 VDD VSS sg13g2_tiehi
Xmain_fsm_top_inst.spi_top_inst.spi_reg.bit_cell5.value_out$_SDFFE_PP0P__174
+ net173 VDD VSS sg13g2_tiehi
Xmain_fsm_top_inst.spi_top_inst.spi_reg.bit_cell6.data_out$_SDFFE_PP0P__175
+ net174 VDD VSS sg13g2_tiehi
Xmain_fsm_top_inst.spi_top_inst.spi_reg.bit_cell6.value_out$_SDFFE_PP0P__176
+ net175 VDD VSS sg13g2_tiehi
Xmain_fsm_top_inst.spi_top_inst.spi_reg.bit_cell7.data_out$_SDFFE_PP0P__177
+ net176 VDD VSS sg13g2_tiehi
Xmain_fsm_top_inst.spi_top_inst.spi_reg.bit_cell7.value_out$_SDFFE_PP0P__178
+ net177 VDD VSS sg13g2_tiehi
Xmain_fsm_top_inst.spi_tx.bypass_rg$_SDFF_PP1__179 net178
+ VDD VSS sg13g2_tiehi
Xmain_fsm_top_inst.spi_tx.data_rg\[0\]$_SDFFE_PP0P__180 net179
+ VDD VSS sg13g2_tiehi
Xmain_fsm_top_inst.spi_tx.data_rg\[1\]$_SDFFE_PP0P__181 net180
+ VDD VSS sg13g2_tiehi
Xmain_fsm_top_inst.spi_tx.data_rg\[2\]$_SDFFE_PP0P__182 net181
+ VDD VSS sg13g2_tiehi
Xmain_fsm_top_inst.spi_tx.data_rg\[3\]$_SDFFE_PP0P__183 net182
+ VDD VSS sg13g2_tiehi
Xmain_fsm_top_inst.spi_tx.data_rg\[4\]$_SDFFE_PP0P__184 net183
+ VDD VSS sg13g2_tiehi
Xmain_fsm_top_inst.spi_tx.data_rg\[5\]$_SDFFE_PP0P__185 net184
+ VDD VSS sg13g2_tiehi
Xmain_fsm_top_inst.spi_tx.data_rg\[6\]$_SDFFE_PP0P__186 net185
+ VDD VSS sg13g2_tiehi
Xmain_fsm_top_inst.spi_tx.data_rg\[7\]$_SDFFE_PP0P__187 net186
+ VDD VSS sg13g2_tiehi
Xserializer_inst.fake_adc.sipo_flip_flops\[0\]$_SDFF_PP0__188
+ net187 VDD VSS sg13g2_tiehi
Xserializer_inst.fake_adc.sipo_flip_flops\[1\]$_SDFF_PP0__189
+ net188 VDD VSS sg13g2_tiehi
Xserializer_inst.fake_adc.sipo_flip_flops\[2\]$_SDFF_PP0__190
+ net189 VDD VSS sg13g2_tiehi
Xserializer_inst.fake_adc.sipo_flip_flops\[3\]$_SDFF_PP0__191
+ net190 VDD VSS sg13g2_tiehi
Xserializer_inst.fake_adc.sipo_flip_flops\[4\]$_SDFF_PP0__192
+ net191 VDD VSS sg13g2_tiehi
Xserializer_inst.fake_adc.sipo_flip_flops\[5\]$_SDFF_PP0__193
+ net192 VDD VSS sg13g2_tiehi
Xserializer_inst.fake_adc.sipo_flip_flops\[6\]$_SDFF_PP0__194
+ net193 VDD VSS sg13g2_tiehi
Xserializer_inst.fake_adc.sipo_flip_flops\[7\]$_SDFF_PP0__195
+ net194 VDD VSS sg13g2_tiehi
Xserializer_inst.fake_adc.sipo_flip_flops\[8\]$_SDFF_PP0__196
+ net195 VDD VSS sg13g2_tiehi
Xserializer_inst.fake_adc.sipo_flip_flops\[9\]$_SDFF_PP0__197
+ net196 VDD VSS sg13g2_tiehi
Xserializer_inst.fake_adc.skid.bypass_rg$_SDFF_PP1__198 net197
+ VDD VSS sg13g2_tiehi
Xserializer_inst.fake_adc.skid.data_rg\[0\]$_SDFFE_PP0P__199
+ net198 VDD VSS sg13g2_tiehi
Xserializer_inst.fake_adc.skid.data_rg\[1\]$_SDFFE_PP0P__200
+ net199 VDD VSS sg13g2_tiehi
Xserializer_inst.fake_adc.skid.data_rg\[2\]$_SDFFE_PP0P__201
+ net200 VDD VSS sg13g2_tiehi
Xserializer_inst.fake_adc.skid.data_rg\[3\]$_SDFFE_PP0P__202
+ net201 VDD VSS sg13g2_tiehi
Xserializer_inst.fake_adc.skid.data_rg\[4\]$_SDFFE_PP0P__203
+ net202 VDD VSS sg13g2_tiehi
Xserializer_inst.fake_adc.skid.data_rg\[5\]$_SDFFE_PP0P__204
+ net203 VDD VSS sg13g2_tiehi
Xserializer_inst.fake_adc.skid.data_rg\[6\]$_SDFFE_PP0P__205
+ net204 VDD VSS sg13g2_tiehi
Xserializer_inst.fake_adc.skid.data_rg\[7\]$_SDFFE_PP0P__206
+ net205 VDD VSS sg13g2_tiehi
Xserializer_inst.fake_adc.skid.data_rg\[8\]$_SDFFE_PP0P__207
+ net206 VDD VSS sg13g2_tiehi
Xserializer_inst.fake_adc.skid.data_rg\[9\]$_SDFFE_PP0P__208
+ net207 VDD VSS sg13g2_tiehi
Xserializer_inst.fake_adc.skid.ready_in$_DFF_P__209 net208
+ VDD VSS sg13g2_tiehi
Xserializer_inst.freeze_delay$_SDFF_PP1__210 net209 VDD VSS
+ sg13g2_tiehi
Xserializer_inst.piso.DATA_IN\[16\]$_SDFF_PP0__211 net210
+ VDD VSS sg13g2_tiehi
Xserializer_inst.piso.DATA_IN\[17\]$_DFF_P__212 net211 VDD
+ VSS sg13g2_tiehi
Xserializer_inst.piso.DATA_IN\[18\]$_DFF_P__213 net212 VDD
+ VSS sg13g2_tiehi
Xserializer_inst.piso.DATA_IN\[19\]$_DFF_P__214 net213 VDD
+ VSS sg13g2_tiehi
Xserializer_inst.piso.piso_flip_flops\[0\]$_SDFF_PP0__215
+ net214 VDD VSS sg13g2_tiehi
Xserializer_inst.piso.piso_flip_flops\[10\]$_SDFF_PP0__216
+ net215 VDD VSS sg13g2_tiehi
Xserializer_inst.piso.piso_flip_flops\[11\]$_SDFF_PP0__217
+ net216 VDD VSS sg13g2_tiehi
Xserializer_inst.piso.piso_flip_flops\[12\]$_SDFF_PP0__218
+ net217 VDD VSS sg13g2_tiehi
Xserializer_inst.piso.piso_flip_flops\[13\]$_SDFF_PP0__219
+ net218 VDD VSS sg13g2_tiehi
Xserializer_inst.piso.piso_flip_flops\[14\]$_SDFF_PP0__220
+ net219 VDD VSS sg13g2_tiehi
Xserializer_inst.piso.piso_flip_flops\[15\]$_SDFF_PP0__221
+ net220 VDD VSS sg13g2_tiehi
Xserializer_inst.piso.piso_flip_flops\[16\]$_SDFF_PP0__222
+ net221 VDD VSS sg13g2_tiehi
Xserializer_inst.piso.piso_flip_flops\[17\]$_SDFF_PP0__223
+ net222 VDD VSS sg13g2_tiehi
Xserializer_inst.piso.piso_flip_flops\[18\]$_SDFF_PP0__224
+ net223 VDD VSS sg13g2_tiehi
Xserializer_inst.piso.piso_flip_flops\[19\]$_SDFF_PP0__225
+ net224 VDD VSS sg13g2_tiehi
Xserializer_inst.piso.piso_flip_flops\[1\]$_SDFF_PP0__226
+ net225 VDD VSS sg13g2_tiehi
Xserializer_inst.piso.piso_flip_flops\[20\]$_SDFF_PP0__227
+ net226 VDD VSS sg13g2_tiehi
Xserializer_inst.piso.piso_flip_flops\[21\]$_SDFF_PP0__228
+ net227 VDD VSS sg13g2_tiehi
Xserializer_inst.piso.piso_flip_flops\[2\]$_SDFF_PP0__229
+ net228 VDD VSS sg13g2_tiehi
Xserializer_inst.piso.piso_flip_flops\[3\]$_SDFF_PP0__230
+ net229 VDD VSS sg13g2_tiehi
Xserializer_inst.piso.piso_flip_flops\[4\]$_SDFF_PP0__231
+ net230 VDD VSS sg13g2_tiehi
Xserializer_inst.piso.piso_flip_flops\[5\]$_SDFF_PP0__232
+ net231 VDD VSS sg13g2_tiehi
Xserializer_inst.piso.piso_flip_flops\[6\]$_SDFF_PP0__233
+ net232 VDD VSS sg13g2_tiehi
Xserializer_inst.piso.piso_flip_flops\[7\]$_SDFF_PP0__234
+ net233 VDD VSS sg13g2_tiehi
Xserializer_inst.piso.piso_flip_flops\[8\]$_SDFF_PP0__235
+ net234 VDD VSS sg13g2_tiehi
Xserializer_inst.piso.piso_flip_flops\[9\]$_SDFF_PP0__236
+ net235 VDD VSS sg13g2_tiehi
Xserializer_inst.scan_out_driver.scan_valid$_SDFFE_PP0P__237
+ net236 VDD VSS sg13g2_tiehi
Xclkbuf_0_CLK clknet_0_CLK CLK VDD VSS sg13g2_buf_16
Xplace562 net561 net562 VDD VSS sg13g2_buf_1
Xplace560 net559 net560 VDD VSS sg13g2_buf_1
Xplace561 net560 net561 VDD VSS sg13g2_buf_1
Xclkbuf_leaf_35_CLK clknet_leaf_35_CLK clknet_3_0__leaf_CLK
+ VDD VSS sg13g2_buf_16
Xplace563 net562 net563 VDD VSS sg13g2_buf_1
Xclkbuf_leaf_31_CLK clknet_leaf_31_CLK clknet_3_1__leaf_CLK
+ VDD VSS sg13g2_buf_16
Xclkbuf_leaf_29_CLK clknet_leaf_29_CLK clknet_3_4__leaf_CLK
+ VDD VSS sg13g2_buf_16
Xplace564 net563 net242 VDD VSS sg13g2_buf_1
Xclkbuf_leaf_30_CLK clknet_leaf_30_CLK clknet_3_4__leaf_CLK
+ VDD VSS sg13g2_buf_16
Xclkbuf_leaf_34_CLK clknet_leaf_34_CLK clknet_3_0__leaf_CLK
+ VDD VSS sg13g2_buf_16
Xclkbuf_leaf_32_CLK clknet_leaf_32_CLK clknet_3_1__leaf_CLK
+ VDD VSS sg13g2_buf_16
Xclkbuf_leaf_33_CLK clknet_leaf_33_CLK clknet_3_1__leaf_CLK
+ VDD VSS sg13g2_buf_16
Xclkbuf_3_0__f_CLK clknet_3_0__leaf_CLK clknet_0_CLK VDD VSS
+ sg13g2_buf_16
Xplace475 net474 _1019_ VDD VSS sg13g2_buf_1
Xplace472 net471 _0144_ VDD VSS sg13g2_buf_1
Xplace492 net491 _0935_ VDD VSS sg13g2_buf_1
Xplace493 net492 _0935_ VDD VSS sg13g2_buf_1
Xplace473 net472 _0710_ VDD VSS sg13g2_buf_1
Xclkbuf_leaf_16_CLK clknet_leaf_16_CLK clknet_3_6__leaf_CLK
+ VDD VSS sg13g2_buf_16
Xclkbuf_leaf_18_CLK clknet_leaf_18_CLK clknet_3_7__leaf_CLK
+ VDD VSS sg13g2_buf_16
Xclkbuf_leaf_20_CLK clknet_leaf_20_CLK clknet_3_7__leaf_CLK
+ VDD VSS sg13g2_buf_16
Xclkbuf_leaf_26_CLK clknet_leaf_26_CLK clknet_3_5__leaf_CLK
+ VDD VSS sg13g2_buf_16
Xclkbuf_leaf_24_CLK clknet_leaf_24_CLK clknet_3_5__leaf_CLK
+ VDD VSS sg13g2_buf_16
Xclkbuf_leaf_23_CLK clknet_leaf_23_CLK clknet_3_5__leaf_CLK
+ VDD VSS sg13g2_buf_16
Xclkbuf_leaf_25_CLK clknet_leaf_25_CLK clknet_3_5__leaf_CLK
+ VDD VSS sg13g2_buf_16
Xclkbuf_leaf_28_CLK clknet_leaf_28_CLK clknet_3_4__leaf_CLK
+ VDD VSS sg13g2_buf_16
Xclkbuf_leaf_27_CLK clknet_leaf_27_CLK clknet_3_4__leaf_CLK
+ VDD VSS sg13g2_buf_16
Xclkbuf_3_2__f_CLK clknet_3_2__leaf_CLK clknet_0_CLK VDD VSS
+ sg13g2_buf_16
Xclkbuf_3_3__f_CLK clknet_3_3__leaf_CLK clknet_0_CLK VDD VSS
+ sg13g2_buf_16
Xclkbuf_3_4__f_CLK clknet_3_4__leaf_CLK clknet_0_CLK VDD VSS
+ sg13g2_buf_16
Xclkbuf_3_5__f_CLK clknet_3_5__leaf_CLK clknet_0_CLK VDD VSS
+ sg13g2_buf_16
Xclkbuf_3_6__f_CLK clknet_3_6__leaf_CLK clknet_0_CLK VDD VSS
+ sg13g2_buf_16
Xclkbuf_3_7__f_CLK clknet_3_7__leaf_CLK clknet_0_CLK VDD VSS
+ sg13g2_buf_16
Xclkload0 _unconnected_0 clknet_3_1__leaf_CLK VDD VSS sg13g2_buf_16
Xclkload1 _unconnected_1 clknet_3_3__leaf_CLK VDD VSS sg13g2_buf_16
Xclkload2 _unconnected_2 clknet_3_5__leaf_CLK VDD VSS sg13g2_buf_16
Xclkload3 _unconnected_3 clknet_3_6__leaf_CLK VDD VSS sg13g2_inv_4
Xclkload4 _unconnected_4 clknet_3_7__leaf_CLK VDD VSS sg13g2_buf_16
Xclkload5 _unconnected_5 clknet_leaf_0_CLK VDD VSS sg13g2_inv_1
Xclkload6 _unconnected_6 clknet_leaf_2_CLK VDD VSS sg13g2_buf_8
Xclkload7 _unconnected_7 clknet_leaf_34_CLK VDD VSS sg13g2_buf_8
Xclkload8 _unconnected_8 clknet_leaf_35_CLK VDD VSS sg13g2_inv_4
Xclkload9 _unconnected_9 clknet_leaf_31_CLK VDD VSS sg13g2_buf_8
Xclkload10 _unconnected_10 clknet_leaf_32_CLK VDD VSS sg13g2_inv_1
Xclkload11 _unconnected_11 clknet_leaf_7_CLK VDD VSS sg13g2_inv_2
Xclkload12 _unconnected_12 clknet_leaf_9_CLK VDD VSS sg13g2_inv_2
Xclkload13 _unconnected_13 clknet_leaf_11_CLK VDD VSS sg13g2_inv_1
Xclkload14 _unconnected_14 clknet_leaf_21_CLK VDD VSS sg13g2_buf_8
Xclkload15 _unconnected_15 clknet_leaf_27_CLK VDD VSS sg13g2_inv_4
Xclkload16 _unconnected_16 clknet_leaf_29_CLK VDD VSS sg13g2_buf_16
Xclkload17 _unconnected_17 clknet_leaf_30_CLK VDD VSS sg13g2_inv_1
Xclkload18 _unconnected_18 clknet_leaf_23_CLK VDD VSS sg13g2_inv_1
Xclkload19 _unconnected_19 clknet_leaf_26_CLK VDD VSS sg13g2_inv_1
Xclkload20 _unconnected_20 clknet_leaf_14_CLK VDD VSS sg13g2_inv_2
Xclkload21 _unconnected_21 clknet_leaf_15_CLK VDD VSS sg13g2_inv_1
Xclkload22 _unconnected_22 clknet_leaf_18_CLK VDD VSS sg13g2_inv_1
Xclkload23 _unconnected_23 clknet_leaf_19_CLK VDD VSS sg13g2_inv_1
Xclkload24 _unconnected_24 clknet_leaf_20_CLK VDD VSS sg13g2_buf_8

XDEC0 VDD VSS sg13g2_decap_8
XDEC1 VDD VSS sg13g2_decap_8
XDEC2 VDD VSS sg13g2_decap_8
XDEC3 VDD VSS sg13g2_decap_8
XDEC4 VDD VSS sg13g2_decap_8
XDEC5 VDD VSS sg13g2_decap_8
XDEC6 VDD VSS sg13g2_decap_8
XDEC7 VDD VSS sg13g2_decap_8
XDEC8 VDD VSS sg13g2_decap_8
XDEC9 VDD VSS sg13g2_decap_8
XDEC10 VDD VSS sg13g2_decap_8
XDEC11 VDD VSS sg13g2_decap_8
XDEC12 VDD VSS sg13g2_decap_8
XDEC13 VDD VSS sg13g2_decap_8
XDEC14 VDD VSS sg13g2_decap_8
XDEC15 VDD VSS sg13g2_decap_8
XDEC16 VDD VSS sg13g2_decap_8
XDEC17 VDD VSS sg13g2_decap_8
XDEC18 VDD VSS sg13g2_decap_8
XDEC19 VDD VSS sg13g2_decap_8
XDEC20 VDD VSS sg13g2_decap_8
XDEC21 VDD VSS sg13g2_decap_8
XDEC22 VDD VSS sg13g2_decap_8
XDEC23 VDD VSS sg13g2_decap_8
XDEC24 VDD VSS sg13g2_decap_8
XDEC25 VDD VSS sg13g2_decap_8
XDEC26 VDD VSS sg13g2_decap_8
XDEC27 VDD VSS sg13g2_decap_8
XDEC28 VDD VSS sg13g2_decap_8
XDEC29 VDD VSS sg13g2_decap_8
XDEC30 VDD VSS sg13g2_decap_8
XDEC31 VDD VSS sg13g2_decap_8
XDEC32 VDD VSS sg13g2_decap_8
XDEC33 VDD VSS sg13g2_decap_8
XDEC34 VDD VSS sg13g2_decap_8
XDEC35 VDD VSS sg13g2_decap_8
XDEC36 VDD VSS sg13g2_decap_8
XDEC37 VDD VSS sg13g2_decap_8
XDEC38 VDD VSS sg13g2_decap_8
XDEC39 VDD VSS sg13g2_decap_8
XDEC40 VDD VSS sg13g2_decap_8
XDEC41 VDD VSS sg13g2_decap_8
XDEC42 VDD VSS sg13g2_decap_8
XDEC43 VDD VSS sg13g2_decap_8
XDEC44 VDD VSS sg13g2_decap_8
XDEC45 VDD VSS sg13g2_decap_8
XDEC46 VDD VSS sg13g2_decap_8
XDEC47 VDD VSS sg13g2_decap_8
XDEC48 VDD VSS sg13g2_decap_8
XDEC49 VDD VSS sg13g2_decap_8
XDEC50 VDD VSS sg13g2_decap_8
XDEC51 VDD VSS sg13g2_decap_8
XDEC52 VDD VSS sg13g2_decap_8
XDEC53 VDD VSS sg13g2_decap_8
XDEC54 VDD VSS sg13g2_decap_8
XDEC55 VDD VSS sg13g2_decap_8
XDEC56 VDD VSS sg13g2_decap_8
XDEC57 VDD VSS sg13g2_decap_8
XDEC58 VDD VSS sg13g2_decap_8
XDEC59 VDD VSS sg13g2_decap_8
XDEC60 VDD VSS sg13g2_decap_8
XDEC61 VDD VSS sg13g2_decap_8
XDEC62 VDD VSS sg13g2_decap_8
XDEC63 VDD VSS sg13g2_decap_8
XDEC64 VDD VSS sg13g2_decap_8
XDEC65 VDD VSS sg13g2_decap_8
XDEC66 VDD VSS sg13g2_decap_8
XDEC67 VDD VSS sg13g2_decap_8
XDEC68 VDD VSS sg13g2_decap_8
XDEC69 VDD VSS sg13g2_decap_8
XDEC70 VDD VSS sg13g2_decap_8
XDEC71 VDD VSS sg13g2_decap_8
XDEC72 VDD VSS sg13g2_decap_8
XDEC73 VDD VSS sg13g2_decap_8
XDEC74 VDD VSS sg13g2_decap_8
XDEC75 VDD VSS sg13g2_decap_8
XDEC76 VDD VSS sg13g2_decap_8
XDEC77 VDD VSS sg13g2_decap_8
XDEC78 VDD VSS sg13g2_decap_8
XDEC79 VDD VSS sg13g2_decap_8
XDEC80 VDD VSS sg13g2_decap_8
XDEC81 VDD VSS sg13g2_decap_8
XDEC82 VDD VSS sg13g2_decap_8
XDEC83 VDD VSS sg13g2_decap_8
XDEC84 VDD VSS sg13g2_decap_8
XDEC85 VDD VSS sg13g2_decap_8
XDEC86 VDD VSS sg13g2_decap_8
XDEC87 VDD VSS sg13g2_decap_8
XDEC88 VDD VSS sg13g2_decap_8
XDEC89 VDD VSS sg13g2_decap_8
XDEC90 VDD VSS sg13g2_decap_8
XDEC91 VDD VSS sg13g2_decap_8
XDEC92 VDD VSS sg13g2_decap_8
XDEC93 VDD VSS sg13g2_decap_8
XDEC94 VDD VSS sg13g2_decap_8
XDEC95 VDD VSS sg13g2_decap_8
XDEC96 VDD VSS sg13g2_decap_8
XDEC97 VDD VSS sg13g2_decap_8
XDEC98 VDD VSS sg13g2_decap_8
XDEC99 VDD VSS sg13g2_decap_8
XDEC100 VDD VSS sg13g2_decap_8
XDEC101 VDD VSS sg13g2_decap_8
XDEC102 VDD VSS sg13g2_decap_8
XDEC103 VDD VSS sg13g2_decap_8
XDEC104 VDD VSS sg13g2_decap_8
XDEC105 VDD VSS sg13g2_decap_8
XDEC106 VDD VSS sg13g2_decap_8
XDEC107 VDD VSS sg13g2_decap_8
XDEC108 VDD VSS sg13g2_decap_8
XDEC109 VDD VSS sg13g2_decap_8
XDEC110 VDD VSS sg13g2_decap_8
XDEC111 VDD VSS sg13g2_decap_8
XDEC112 VDD VSS sg13g2_decap_8
XDEC113 VDD VSS sg13g2_decap_8
XDEC114 VDD VSS sg13g2_decap_8
XDEC115 VDD VSS sg13g2_decap_8
XDEC116 VDD VSS sg13g2_decap_8
XDEC117 VDD VSS sg13g2_decap_8
XDEC118 VDD VSS sg13g2_decap_8
XDEC119 VDD VSS sg13g2_decap_8
XDEC120 VDD VSS sg13g2_decap_8
XDEC121 VDD VSS sg13g2_decap_8
XDEC122 VDD VSS sg13g2_decap_8
XDEC123 VDD VSS sg13g2_decap_8
XDEC124 VDD VSS sg13g2_decap_8
XDEC125 VDD VSS sg13g2_decap_8
XDEC126 VDD VSS sg13g2_decap_8
XDEC127 VDD VSS sg13g2_decap_8
XDEC128 VDD VSS sg13g2_decap_8
XDEC129 VDD VSS sg13g2_decap_8
XDEC130 VDD VSS sg13g2_decap_8
XDEC131 VDD VSS sg13g2_decap_8
XDEC132 VDD VSS sg13g2_decap_8
XDEC133 VDD VSS sg13g2_decap_8
XDEC134 VDD VSS sg13g2_decap_8
XDEC135 VDD VSS sg13g2_decap_8
XDEC136 VDD VSS sg13g2_decap_8
XDEC137 VDD VSS sg13g2_decap_8
XDEC138 VDD VSS sg13g2_decap_8
XDEC139 VDD VSS sg13g2_decap_8
XDEC140 VDD VSS sg13g2_decap_8
XDEC141 VDD VSS sg13g2_decap_8
XDEC142 VDD VSS sg13g2_decap_8
XDEC143 VDD VSS sg13g2_decap_8
XDEC144 VDD VSS sg13g2_decap_8
XDEC145 VDD VSS sg13g2_decap_8
XDEC146 VDD VSS sg13g2_decap_8
XDEC147 VDD VSS sg13g2_decap_8
XDEC148 VDD VSS sg13g2_decap_8
XDEC149 VDD VSS sg13g2_decap_8
XDEC150 VDD VSS sg13g2_decap_8
XDEC151 VDD VSS sg13g2_decap_8
XDEC152 VDD VSS sg13g2_decap_8
XDEC153 VDD VSS sg13g2_decap_8
XDEC154 VDD VSS sg13g2_decap_8
XDEC155 VDD VSS sg13g2_decap_8
XDEC156 VDD VSS sg13g2_decap_8
XDEC157 VDD VSS sg13g2_decap_8
XDEC158 VDD VSS sg13g2_decap_8
XDEC159 VDD VSS sg13g2_decap_8
XDEC160 VDD VSS sg13g2_decap_8
XDEC161 VDD VSS sg13g2_decap_8
XDEC162 VDD VSS sg13g2_decap_8
XDEC163 VDD VSS sg13g2_decap_8
XDEC164 VDD VSS sg13g2_decap_8
XDEC165 VDD VSS sg13g2_decap_8
XDEC166 VDD VSS sg13g2_decap_8
XDEC167 VDD VSS sg13g2_decap_8
XDEC168 VDD VSS sg13g2_decap_8
XDEC169 VDD VSS sg13g2_decap_8
XDEC170 VDD VSS sg13g2_decap_8
XDEC171 VDD VSS sg13g2_decap_8
XDEC172 VDD VSS sg13g2_decap_8
XDEC173 VDD VSS sg13g2_decap_8
XDEC174 VDD VSS sg13g2_decap_8
XDEC175 VDD VSS sg13g2_decap_8
XDEC176 VDD VSS sg13g2_decap_8
XDEC177 VDD VSS sg13g2_decap_8
XDEC178 VDD VSS sg13g2_decap_8
XDEC179 VDD VSS sg13g2_decap_8
XDEC180 VDD VSS sg13g2_decap_8
XDEC181 VDD VSS sg13g2_decap_8
XDEC182 VDD VSS sg13g2_decap_8
XDEC183 VDD VSS sg13g2_decap_8
XDEC184 VDD VSS sg13g2_decap_8
XDEC185 VDD VSS sg13g2_decap_8
XDEC186 VDD VSS sg13g2_decap_8
XDEC187 VDD VSS sg13g2_decap_8
XDEC188 VDD VSS sg13g2_decap_8
XDEC189 VDD VSS sg13g2_decap_8
XDEC190 VDD VSS sg13g2_decap_8
XDEC191 VDD VSS sg13g2_decap_8
XDEC192 VDD VSS sg13g2_decap_8
XDEC193 VDD VSS sg13g2_decap_8
XDEC194 VDD VSS sg13g2_decap_8
XDEC195 VDD VSS sg13g2_decap_8
XDEC196 VDD VSS sg13g2_decap_8
XDEC197 VDD VSS sg13g2_decap_8
XDEC198 VDD VSS sg13g2_decap_8
XDEC199 VDD VSS sg13g2_decap_8
XDEC200 VDD VSS sg13g2_decap_8
XDEC201 VDD VSS sg13g2_decap_8
XDEC202 VDD VSS sg13g2_decap_8
XDEC203 VDD VSS sg13g2_decap_8
XDEC204 VDD VSS sg13g2_decap_8
XDEC205 VDD VSS sg13g2_decap_8
XDEC206 VDD VSS sg13g2_decap_8
XDEC207 VDD VSS sg13g2_decap_8
XDEC208 VDD VSS sg13g2_decap_8
XDEC209 VDD VSS sg13g2_decap_8
XDEC210 VDD VSS sg13g2_decap_8
XDEC211 VDD VSS sg13g2_decap_8
XDEC212 VDD VSS sg13g2_decap_8
XDEC213 VDD VSS sg13g2_decap_8
XDEC214 VDD VSS sg13g2_decap_8
XDEC215 VDD VSS sg13g2_decap_8
XDEC216 VDD VSS sg13g2_decap_8
XDEC217 VDD VSS sg13g2_decap_8
XDEC218 VDD VSS sg13g2_decap_8
XDEC219 VDD VSS sg13g2_decap_8
XDEC220 VDD VSS sg13g2_decap_8
XDEC221 VDD VSS sg13g2_decap_8
XDEC222 VDD VSS sg13g2_decap_8
XDEC223 VDD VSS sg13g2_decap_8
XDEC224 VDD VSS sg13g2_decap_8
XDEC225 VDD VSS sg13g2_decap_8
XDEC226 VDD VSS sg13g2_decap_8
XDEC227 VDD VSS sg13g2_decap_8
XDEC228 VDD VSS sg13g2_decap_8
XDEC229 VDD VSS sg13g2_decap_8
XDEC230 VDD VSS sg13g2_decap_8
XDEC231 VDD VSS sg13g2_decap_8
XDEC232 VDD VSS sg13g2_decap_8
XDEC233 VDD VSS sg13g2_decap_8
XDEC234 VDD VSS sg13g2_decap_8
XDEC235 VDD VSS sg13g2_decap_8
XDEC236 VDD VSS sg13g2_decap_8
XDEC237 VDD VSS sg13g2_decap_8
XDEC238 VDD VSS sg13g2_decap_8
XDEC239 VDD VSS sg13g2_decap_8
XDEC240 VDD VSS sg13g2_decap_8
XDEC241 VDD VSS sg13g2_decap_8
XDEC242 VDD VSS sg13g2_decap_8
XDEC243 VDD VSS sg13g2_decap_8
XDEC244 VDD VSS sg13g2_decap_8
XDEC245 VDD VSS sg13g2_decap_8
XDEC246 VDD VSS sg13g2_decap_8
XDEC247 VDD VSS sg13g2_decap_8
XDEC248 VDD VSS sg13g2_decap_8
XDEC249 VDD VSS sg13g2_decap_8
XDEC250 VDD VSS sg13g2_decap_8
XDEC251 VDD VSS sg13g2_decap_8
XDEC252 VDD VSS sg13g2_decap_8
XDEC253 VDD VSS sg13g2_decap_8
XDEC254 VDD VSS sg13g2_decap_8
XDEC255 VDD VSS sg13g2_decap_8
XDEC256 VDD VSS sg13g2_decap_8
XDEC257 VDD VSS sg13g2_decap_8
XDEC258 VDD VSS sg13g2_decap_8
XDEC259 VDD VSS sg13g2_decap_8
XDEC260 VDD VSS sg13g2_decap_8
XDEC261 VDD VSS sg13g2_decap_8
XDEC262 VDD VSS sg13g2_decap_8
XDEC263 VDD VSS sg13g2_decap_8
XDEC264 VDD VSS sg13g2_decap_8
XDEC265 VDD VSS sg13g2_decap_8
XDEC266 VDD VSS sg13g2_decap_8
XDEC267 VDD VSS sg13g2_decap_8
XDEC268 VDD VSS sg13g2_decap_8
XDEC269 VDD VSS sg13g2_decap_8
XDEC270 VDD VSS sg13g2_decap_8
XDEC271 VDD VSS sg13g2_decap_8
XDEC272 VDD VSS sg13g2_decap_8
XDEC273 VDD VSS sg13g2_decap_8
XDEC274 VDD VSS sg13g2_decap_8
XDEC275 VDD VSS sg13g2_decap_8
XDEC276 VDD VSS sg13g2_decap_8
XDEC277 VDD VSS sg13g2_decap_8
XDEC278 VDD VSS sg13g2_decap_8
XDEC279 VDD VSS sg13g2_decap_8
XDEC280 VDD VSS sg13g2_decap_8
XDEC281 VDD VSS sg13g2_decap_8
XDEC282 VDD VSS sg13g2_decap_8
XDEC283 VDD VSS sg13g2_decap_8
XDEC284 VDD VSS sg13g2_decap_8
XDEC285 VDD VSS sg13g2_decap_8
XDEC286 VDD VSS sg13g2_decap_8
XDEC287 VDD VSS sg13g2_decap_8
XDEC288 VDD VSS sg13g2_decap_8
XDEC289 VDD VSS sg13g2_decap_8
XDEC290 VDD VSS sg13g2_decap_8
XDEC291 VDD VSS sg13g2_decap_8
XDEC292 VDD VSS sg13g2_decap_8
XDEC293 VDD VSS sg13g2_decap_8
XDEC294 VDD VSS sg13g2_decap_8
XDEC295 VDD VSS sg13g2_decap_8
XDEC296 VDD VSS sg13g2_decap_8
XDEC297 VDD VSS sg13g2_decap_8
XDEC298 VDD VSS sg13g2_decap_8
XDEC299 VDD VSS sg13g2_decap_8
XDEC300 VDD VSS sg13g2_decap_8
XDEC301 VDD VSS sg13g2_decap_8
XDEC302 VDD VSS sg13g2_decap_8
XDEC303 VDD VSS sg13g2_decap_8
XDEC304 VDD VSS sg13g2_decap_8
XDEC305 VDD VSS sg13g2_decap_8
XDEC306 VDD VSS sg13g2_decap_8
XDEC307 VDD VSS sg13g2_decap_8
XDEC308 VDD VSS sg13g2_decap_8
XDEC309 VDD VSS sg13g2_decap_8
XDEC310 VDD VSS sg13g2_decap_8
XDEC311 VDD VSS sg13g2_decap_8
XDEC312 VDD VSS sg13g2_decap_8
XDEC313 VDD VSS sg13g2_decap_8
XDEC314 VDD VSS sg13g2_decap_8
XDEC315 VDD VSS sg13g2_decap_8
XDEC316 VDD VSS sg13g2_decap_8
XDEC317 VDD VSS sg13g2_decap_8
XDEC318 VDD VSS sg13g2_decap_8
XDEC319 VDD VSS sg13g2_decap_8
XDEC320 VDD VSS sg13g2_decap_8
XDEC321 VDD VSS sg13g2_decap_8
XDEC322 VDD VSS sg13g2_decap_8
XDEC323 VDD VSS sg13g2_decap_8
XDEC324 VDD VSS sg13g2_decap_8
XDEC325 VDD VSS sg13g2_decap_8
XDEC326 VDD VSS sg13g2_decap_8
XDEC327 VDD VSS sg13g2_decap_8
XDEC328 VDD VSS sg13g2_decap_8
XDEC329 VDD VSS sg13g2_decap_8
XDEC330 VDD VSS sg13g2_decap_8
XDEC331 VDD VSS sg13g2_decap_8
XDEC332 VDD VSS sg13g2_decap_8
XDEC333 VDD VSS sg13g2_decap_8
XDEC334 VDD VSS sg13g2_decap_8
XDEC335 VDD VSS sg13g2_decap_8
XDEC336 VDD VSS sg13g2_decap_8
XDEC337 VDD VSS sg13g2_decap_8
XDEC338 VDD VSS sg13g2_decap_8
XDEC339 VDD VSS sg13g2_decap_8
XDEC340 VDD VSS sg13g2_decap_8
XDEC341 VDD VSS sg13g2_decap_8
XDEC342 VDD VSS sg13g2_decap_8
XDEC343 VDD VSS sg13g2_decap_8
XDEC344 VDD VSS sg13g2_decap_8
XDEC345 VDD VSS sg13g2_decap_8
XDEC346 VDD VSS sg13g2_decap_8
XDEC347 VDD VSS sg13g2_decap_8
XDEC348 VDD VSS sg13g2_decap_8
XDEC349 VDD VSS sg13g2_decap_8
XDEC350 VDD VSS sg13g2_decap_8
XDEC351 VDD VSS sg13g2_decap_8
XDEC352 VDD VSS sg13g2_decap_8
XDEC353 VDD VSS sg13g2_decap_8
XDEC354 VDD VSS sg13g2_decap_8
XDEC355 VDD VSS sg13g2_decap_8
XDEC356 VDD VSS sg13g2_decap_8
XDEC357 VDD VSS sg13g2_decap_8
XDEC358 VDD VSS sg13g2_decap_8
XDEC359 VDD VSS sg13g2_decap_8
XDEC360 VDD VSS sg13g2_decap_8
XDEC361 VDD VSS sg13g2_decap_8
XDEC362 VDD VSS sg13g2_decap_8
XDEC363 VDD VSS sg13g2_decap_8
XDEC364 VDD VSS sg13g2_decap_8
XDEC365 VDD VSS sg13g2_decap_8
XDEC366 VDD VSS sg13g2_decap_8
XDEC367 VDD VSS sg13g2_decap_8
XDEC368 VDD VSS sg13g2_decap_8
XDEC369 VDD VSS sg13g2_decap_8
XDEC370 VDD VSS sg13g2_decap_8
XDEC371 VDD VSS sg13g2_decap_8
XDEC372 VDD VSS sg13g2_decap_8
XDEC373 VDD VSS sg13g2_decap_8
XDEC374 VDD VSS sg13g2_decap_8
XDEC375 VDD VSS sg13g2_decap_8
XDEC376 VDD VSS sg13g2_decap_8
XDEC377 VDD VSS sg13g2_decap_8
XDEC378 VDD VSS sg13g2_decap_8
XDEC379 VDD VSS sg13g2_decap_8
XDEC380 VDD VSS sg13g2_decap_8
XDEC381 VDD VSS sg13g2_decap_8
XDEC382 VDD VSS sg13g2_decap_8
XDEC383 VDD VSS sg13g2_decap_8
XDEC384 VDD VSS sg13g2_decap_8
XDEC385 VDD VSS sg13g2_decap_8
XDEC386 VDD VSS sg13g2_decap_8
XDEC387 VDD VSS sg13g2_decap_8
XDEC388 VDD VSS sg13g2_decap_8
XDEC389 VDD VSS sg13g2_decap_8
XDEC390 VDD VSS sg13g2_decap_8
XDEC391 VDD VSS sg13g2_decap_8
XDEC392 VDD VSS sg13g2_decap_8
XDEC393 VDD VSS sg13g2_decap_8
XDEC394 VDD VSS sg13g2_decap_8
XDEC395 VDD VSS sg13g2_decap_8
XDEC396 VDD VSS sg13g2_decap_8
XDEC397 VDD VSS sg13g2_decap_8
XDEC398 VDD VSS sg13g2_decap_8
XDEC399 VDD VSS sg13g2_decap_8
XDEC400 VDD VSS sg13g2_decap_8
XDEC401 VDD VSS sg13g2_decap_8
XDEC402 VDD VSS sg13g2_decap_8
XDEC403 VDD VSS sg13g2_decap_8
XDEC404 VDD VSS sg13g2_decap_8
XDEC405 VDD VSS sg13g2_decap_8
XDEC406 VDD VSS sg13g2_decap_8
XDEC407 VDD VSS sg13g2_decap_8
XDEC408 VDD VSS sg13g2_decap_8
XDEC409 VDD VSS sg13g2_decap_8
XDEC410 VDD VSS sg13g2_decap_8
XDEC411 VDD VSS sg13g2_decap_8
XDEC412 VDD VSS sg13g2_decap_8
XDEC413 VDD VSS sg13g2_decap_8
XDEC414 VDD VSS sg13g2_decap_8
XDEC415 VDD VSS sg13g2_decap_8
XDEC416 VDD VSS sg13g2_decap_8
XDEC417 VDD VSS sg13g2_decap_8
XDEC418 VDD VSS sg13g2_decap_8
XDEC419 VDD VSS sg13g2_decap_8
XDEC420 VDD VSS sg13g2_decap_8
XDEC421 VDD VSS sg13g2_decap_8
XDEC422 VDD VSS sg13g2_decap_8
XDEC423 VDD VSS sg13g2_decap_8
XDEC424 VDD VSS sg13g2_decap_8
XDEC425 VDD VSS sg13g2_decap_8
XDEC426 VDD VSS sg13g2_decap_8
XDEC427 VDD VSS sg13g2_decap_8
XDEC428 VDD VSS sg13g2_decap_8
XDEC429 VDD VSS sg13g2_decap_8
XDEC430 VDD VSS sg13g2_decap_8
XDEC431 VDD VSS sg13g2_decap_8
XDEC432 VDD VSS sg13g2_decap_8
XDEC433 VDD VSS sg13g2_decap_8
XDEC434 VDD VSS sg13g2_decap_8
XDEC435 VDD VSS sg13g2_decap_8
XDEC436 VDD VSS sg13g2_decap_8
XDEC437 VDD VSS sg13g2_decap_8
XDEC438 VDD VSS sg13g2_decap_8
XDEC439 VDD VSS sg13g2_decap_8
XDEC440 VDD VSS sg13g2_decap_8
XDEC441 VDD VSS sg13g2_decap_8
XDEC442 VDD VSS sg13g2_decap_8
XDEC443 VDD VSS sg13g2_decap_8
XDEC444 VDD VSS sg13g2_decap_8
XDEC445 VDD VSS sg13g2_decap_8
XDEC446 VDD VSS sg13g2_decap_8
XDEC447 VDD VSS sg13g2_decap_8
XDEC448 VDD VSS sg13g2_decap_8
XDEC449 VDD VSS sg13g2_decap_8
XDEC450 VDD VSS sg13g2_decap_8
XDEC451 VDD VSS sg13g2_decap_8
XDEC452 VDD VSS sg13g2_decap_8
XDEC453 VDD VSS sg13g2_decap_8
XDEC454 VDD VSS sg13g2_decap_8
XDEC455 VDD VSS sg13g2_decap_8
XDEC456 VDD VSS sg13g2_decap_8
XDEC457 VDD VSS sg13g2_decap_8
XDEC458 VDD VSS sg13g2_decap_8
XDEC459 VDD VSS sg13g2_decap_8
XDEC460 VDD VSS sg13g2_decap_8
XDEC461 VDD VSS sg13g2_decap_8
XDEC462 VDD VSS sg13g2_decap_8
XDEC463 VDD VSS sg13g2_decap_8
XDEC464 VDD VSS sg13g2_decap_8
XDEC465 VDD VSS sg13g2_decap_8
XDEC466 VDD VSS sg13g2_decap_8
XDEC467 VDD VSS sg13g2_decap_8
XDEC468 VDD VSS sg13g2_decap_8
XDEC469 VDD VSS sg13g2_decap_8
XDEC470 VDD VSS sg13g2_decap_8
XDEC471 VDD VSS sg13g2_decap_8
XDEC472 VDD VSS sg13g2_decap_8
XDEC473 VDD VSS sg13g2_decap_8
XDEC474 VDD VSS sg13g2_decap_8
XDEC475 VDD VSS sg13g2_decap_8
XDEC476 VDD VSS sg13g2_decap_8
XDEC477 VDD VSS sg13g2_decap_8
XDEC478 VDD VSS sg13g2_decap_8
XDEC479 VDD VSS sg13g2_decap_8
XDEC480 VDD VSS sg13g2_decap_8
XDEC481 VDD VSS sg13g2_decap_8
XDEC482 VDD VSS sg13g2_decap_8
XDEC483 VDD VSS sg13g2_decap_8
XDEC484 VDD VSS sg13g2_decap_8
XDEC485 VDD VSS sg13g2_decap_8
XDEC486 VDD VSS sg13g2_decap_8
XDEC487 VDD VSS sg13g2_decap_8
XDEC488 VDD VSS sg13g2_decap_8
XDEC489 VDD VSS sg13g2_decap_8
XDEC490 VDD VSS sg13g2_decap_8
XDEC491 VDD VSS sg13g2_decap_8
XDEC492 VDD VSS sg13g2_decap_8
XDEC493 VDD VSS sg13g2_decap_8
XDEC494 VDD VSS sg13g2_decap_8
XDEC495 VDD VSS sg13g2_decap_8
XDEC496 VDD VSS sg13g2_decap_8
XDEC497 VDD VSS sg13g2_decap_8
XDEC498 VDD VSS sg13g2_decap_8
XDEC499 VDD VSS sg13g2_decap_8
XDEC500 VDD VSS sg13g2_decap_8
XDEC501 VDD VSS sg13g2_decap_8
XDEC502 VDD VSS sg13g2_decap_8
XDEC503 VDD VSS sg13g2_decap_8
XDEC504 VDD VSS sg13g2_decap_8
XDEC505 VDD VSS sg13g2_decap_8
XDEC506 VDD VSS sg13g2_decap_8
XDEC507 VDD VSS sg13g2_decap_8
XDEC508 VDD VSS sg13g2_decap_8
XDEC509 VDD VSS sg13g2_decap_8
XDEC510 VDD VSS sg13g2_decap_8
XDEC511 VDD VSS sg13g2_decap_8
XDEC512 VDD VSS sg13g2_decap_8
XDEC513 VDD VSS sg13g2_decap_8
XDEC514 VDD VSS sg13g2_decap_8
XDEC515 VDD VSS sg13g2_decap_8
XDEC516 VDD VSS sg13g2_decap_8
XDEC517 VDD VSS sg13g2_decap_8
XDEC518 VDD VSS sg13g2_decap_8
XDEC519 VDD VSS sg13g2_decap_8
XDEC520 VDD VSS sg13g2_decap_8
XDEC521 VDD VSS sg13g2_decap_8
XDEC522 VDD VSS sg13g2_decap_8
XDEC523 VDD VSS sg13g2_decap_8
XDEC524 VDD VSS sg13g2_decap_8
XDEC525 VDD VSS sg13g2_decap_8
XDEC526 VDD VSS sg13g2_decap_8
XDEC527 VDD VSS sg13g2_decap_8
XDEC528 VDD VSS sg13g2_decap_8
XDEC529 VDD VSS sg13g2_decap_8
XDEC530 VDD VSS sg13g2_decap_8
XDEC531 VDD VSS sg13g2_decap_8
XDEC532 VDD VSS sg13g2_decap_8
XDEC533 VDD VSS sg13g2_decap_8
XDEC534 VDD VSS sg13g2_decap_8
XDEC535 VDD VSS sg13g2_decap_8
XDEC536 VDD VSS sg13g2_decap_8
XDEC537 VDD VSS sg13g2_decap_8
XDEC538 VDD VSS sg13g2_decap_8
XDEC539 VDD VSS sg13g2_decap_8
XDEC540 VDD VSS sg13g2_decap_8
XDEC541 VDD VSS sg13g2_decap_8
XDEC542 VDD VSS sg13g2_decap_8
XDEC543 VDD VSS sg13g2_decap_8
XDEC544 VDD VSS sg13g2_decap_8
XDEC545 VDD VSS sg13g2_decap_8
XDEC546 VDD VSS sg13g2_decap_8
XDEC547 VDD VSS sg13g2_decap_8
XDEC548 VDD VSS sg13g2_decap_8
XDEC549 VDD VSS sg13g2_decap_8
XDEC550 VDD VSS sg13g2_decap_8
XDEC551 VDD VSS sg13g2_decap_8
XDEC552 VDD VSS sg13g2_decap_8
XDEC553 VDD VSS sg13g2_decap_8
XDEC554 VDD VSS sg13g2_decap_8
XDEC555 VDD VSS sg13g2_decap_8
XDEC556 VDD VSS sg13g2_decap_8
XDEC557 VDD VSS sg13g2_decap_8
XDEC558 VDD VSS sg13g2_decap_8
XDEC559 VDD VSS sg13g2_decap_8
XDEC560 VDD VSS sg13g2_decap_8
XDEC561 VDD VSS sg13g2_decap_8
XDEC562 VDD VSS sg13g2_decap_8
XDEC563 VDD VSS sg13g2_decap_8
XDEC564 VDD VSS sg13g2_decap_8
XDEC565 VDD VSS sg13g2_decap_8
XDEC566 VDD VSS sg13g2_decap_8
XDEC567 VDD VSS sg13g2_decap_8
XDEC568 VDD VSS sg13g2_decap_8
XDEC569 VDD VSS sg13g2_decap_8
XDEC570 VDD VSS sg13g2_decap_8
XDEC571 VDD VSS sg13g2_decap_8
XDEC572 VDD VSS sg13g2_decap_8
XDEC573 VDD VSS sg13g2_decap_8
XDEC574 VDD VSS sg13g2_decap_8
XDEC575 VDD VSS sg13g2_decap_8
XDEC576 VDD VSS sg13g2_decap_8
XDEC577 VDD VSS sg13g2_decap_8
XDEC578 VDD VSS sg13g2_decap_8
XDEC579 VDD VSS sg13g2_decap_8
XDEC580 VDD VSS sg13g2_decap_8
XDEC581 VDD VSS sg13g2_decap_8
XDEC582 VDD VSS sg13g2_decap_8
XDEC583 VDD VSS sg13g2_decap_8
XDEC584 VDD VSS sg13g2_decap_8
XDEC585 VDD VSS sg13g2_decap_8
XDEC586 VDD VSS sg13g2_decap_8
XDEC587 VDD VSS sg13g2_decap_8
XDEC588 VDD VSS sg13g2_decap_8
XDEC589 VDD VSS sg13g2_decap_8
XDEC590 VDD VSS sg13g2_decap_8
XDEC591 VDD VSS sg13g2_decap_8
XDEC592 VDD VSS sg13g2_decap_8
XDEC593 VDD VSS sg13g2_decap_8
XDEC594 VDD VSS sg13g2_decap_8
XDEC595 VDD VSS sg13g2_decap_8
XDEC596 VDD VSS sg13g2_decap_8
XDEC597 VDD VSS sg13g2_decap_8
XDEC598 VDD VSS sg13g2_decap_8
XDEC599 VDD VSS sg13g2_decap_8
XDEC600 VDD VSS sg13g2_decap_8
XDEC601 VDD VSS sg13g2_decap_8
XDEC602 VDD VSS sg13g2_decap_8
XDEC603 VDD VSS sg13g2_decap_8
XDEC604 VDD VSS sg13g2_decap_8
XDEC605 VDD VSS sg13g2_decap_8
XDEC606 VDD VSS sg13g2_decap_8
XDEC607 VDD VSS sg13g2_decap_8
XDEC608 VDD VSS sg13g2_decap_8
XDEC609 VDD VSS sg13g2_decap_8
XDEC610 VDD VSS sg13g2_decap_8
XDEC611 VDD VSS sg13g2_decap_8
XDEC612 VDD VSS sg13g2_decap_8
XDEC613 VDD VSS sg13g2_decap_8
XDEC614 VDD VSS sg13g2_decap_8
XDEC615 VDD VSS sg13g2_decap_8
XDEC616 VDD VSS sg13g2_decap_8
XDEC617 VDD VSS sg13g2_decap_8
XDEC618 VDD VSS sg13g2_decap_8
XDEC619 VDD VSS sg13g2_decap_8
XDEC620 VDD VSS sg13g2_decap_8
XDEC621 VDD VSS sg13g2_decap_8
XDEC622 VDD VSS sg13g2_decap_8
XDEC623 VDD VSS sg13g2_decap_8
XDEC624 VDD VSS sg13g2_decap_8
XDEC625 VDD VSS sg13g2_decap_8
XDEC626 VDD VSS sg13g2_decap_8
XDEC627 VDD VSS sg13g2_decap_8
XDEC628 VDD VSS sg13g2_decap_8
XDEC629 VDD VSS sg13g2_decap_8
XDEC630 VDD VSS sg13g2_decap_8
XDEC631 VDD VSS sg13g2_decap_8
XDEC632 VDD VSS sg13g2_decap_8
XDEC633 VDD VSS sg13g2_decap_8
XDEC634 VDD VSS sg13g2_decap_8
XDEC635 VDD VSS sg13g2_decap_8
XDEC636 VDD VSS sg13g2_decap_8
XDEC637 VDD VSS sg13g2_decap_8
XDEC638 VDD VSS sg13g2_decap_8
XDEC639 VDD VSS sg13g2_decap_8
XDEC640 VDD VSS sg13g2_decap_8
XDEC641 VDD VSS sg13g2_decap_8
XDEC642 VDD VSS sg13g2_decap_8
XDEC643 VDD VSS sg13g2_decap_8
XDEC644 VDD VSS sg13g2_decap_8
XDEC645 VDD VSS sg13g2_decap_8
XDEC646 VDD VSS sg13g2_decap_8
XDEC647 VDD VSS sg13g2_decap_8
XDEC648 VDD VSS sg13g2_decap_8
XDEC649 VDD VSS sg13g2_decap_8
XDEC650 VDD VSS sg13g2_decap_8
XDEC651 VDD VSS sg13g2_decap_8
XDEC652 VDD VSS sg13g2_decap_8
XDEC653 VDD VSS sg13g2_decap_8
XDEC654 VDD VSS sg13g2_decap_8
XDEC655 VDD VSS sg13g2_decap_8
XDEC656 VDD VSS sg13g2_decap_8
XDEC657 VDD VSS sg13g2_decap_8
XDEC658 VDD VSS sg13g2_decap_8
XDEC659 VDD VSS sg13g2_decap_8
XDEC660 VDD VSS sg13g2_decap_8
XDEC661 VDD VSS sg13g2_decap_8
XDEC662 VDD VSS sg13g2_decap_8
XDEC663 VDD VSS sg13g2_decap_8
XDEC664 VDD VSS sg13g2_decap_8
XDEC665 VDD VSS sg13g2_decap_8
XDEC666 VDD VSS sg13g2_decap_8
XDEC667 VDD VSS sg13g2_decap_8
XDEC668 VDD VSS sg13g2_decap_8
XDEC669 VDD VSS sg13g2_decap_8
XDEC670 VDD VSS sg13g2_decap_8
XDEC671 VDD VSS sg13g2_decap_8
XDEC672 VDD VSS sg13g2_decap_8
XDEC673 VDD VSS sg13g2_decap_8
XDEC674 VDD VSS sg13g2_decap_8
XDEC675 VDD VSS sg13g2_decap_8
XDEC676 VDD VSS sg13g2_decap_8
XDEC677 VDD VSS sg13g2_decap_8
XDEC678 VDD VSS sg13g2_decap_8
XDEC679 VDD VSS sg13g2_decap_8
XDEC680 VDD VSS sg13g2_decap_8
XDEC681 VDD VSS sg13g2_decap_8
XDEC682 VDD VSS sg13g2_decap_8
XDEC683 VDD VSS sg13g2_decap_8
XDEC684 VDD VSS sg13g2_decap_8
XDEC685 VDD VSS sg13g2_decap_8
XDEC686 VDD VSS sg13g2_decap_8
XDEC687 VDD VSS sg13g2_decap_8
XDEC688 VDD VSS sg13g2_decap_8
XDEC689 VDD VSS sg13g2_decap_8
XDEC690 VDD VSS sg13g2_decap_8
XDEC691 VDD VSS sg13g2_decap_8
XDEC692 VDD VSS sg13g2_decap_8
XDEC693 VDD VSS sg13g2_decap_8
XDEC694 VDD VSS sg13g2_decap_8
XDEC695 VDD VSS sg13g2_decap_8
XDEC696 VDD VSS sg13g2_decap_8
XDEC697 VDD VSS sg13g2_decap_8
XDEC698 VDD VSS sg13g2_decap_8
XDEC699 VDD VSS sg13g2_decap_8
XDEC700 VDD VSS sg13g2_decap_8
XDEC701 VDD VSS sg13g2_decap_8
XDEC702 VDD VSS sg13g2_decap_8
XDEC703 VDD VSS sg13g2_decap_8
XDEC704 VDD VSS sg13g2_decap_8
XDEC705 VDD VSS sg13g2_decap_8
XDEC706 VDD VSS sg13g2_decap_8
XDEC707 VDD VSS sg13g2_decap_8
XDEC708 VDD VSS sg13g2_decap_8
XDEC709 VDD VSS sg13g2_decap_8
XDEC710 VDD VSS sg13g2_decap_8
XDEC711 VDD VSS sg13g2_decap_8
XDEC712 VDD VSS sg13g2_decap_8
XDEC713 VDD VSS sg13g2_decap_8
XDEC714 VDD VSS sg13g2_decap_8
XDEC715 VDD VSS sg13g2_decap_8
XDEC716 VDD VSS sg13g2_decap_8
XDEC717 VDD VSS sg13g2_decap_8
XDEC718 VDD VSS sg13g2_decap_8
XDEC719 VDD VSS sg13g2_decap_8
XDEC720 VDD VSS sg13g2_decap_8
XDEC721 VDD VSS sg13g2_decap_8
XDEC722 VDD VSS sg13g2_decap_8
XDEC723 VDD VSS sg13g2_decap_8
XDEC724 VDD VSS sg13g2_decap_8
XDEC725 VDD VSS sg13g2_decap_8
XDEC726 VDD VSS sg13g2_decap_8
XDEC727 VDD VSS sg13g2_decap_8
XDEC728 VDD VSS sg13g2_decap_8
XDEC729 VDD VSS sg13g2_decap_8
XDEC730 VDD VSS sg13g2_decap_8
XDEC731 VDD VSS sg13g2_decap_8
XDEC732 VDD VSS sg13g2_decap_8
XDEC733 VDD VSS sg13g2_decap_8
XDEC734 VDD VSS sg13g2_decap_8
XDEC735 VDD VSS sg13g2_decap_8
XDEC736 VDD VSS sg13g2_decap_8
XDEC737 VDD VSS sg13g2_decap_8
XDEC738 VDD VSS sg13g2_decap_8
XDEC739 VDD VSS sg13g2_decap_8
XDEC740 VDD VSS sg13g2_decap_8
XDEC741 VDD VSS sg13g2_decap_8
XDEC742 VDD VSS sg13g2_decap_8
XDEC743 VDD VSS sg13g2_decap_8
XDEC744 VDD VSS sg13g2_decap_8
XDEC745 VDD VSS sg13g2_decap_8
XDEC746 VDD VSS sg13g2_decap_8
XDEC747 VDD VSS sg13g2_decap_8
XDEC748 VDD VSS sg13g2_decap_8
XDEC749 VDD VSS sg13g2_decap_8
XDEC750 VDD VSS sg13g2_decap_8
XDEC751 VDD VSS sg13g2_decap_8
XDEC752 VDD VSS sg13g2_decap_8
XDEC753 VDD VSS sg13g2_decap_8
XDEC754 VDD VSS sg13g2_decap_8
XDEC755 VDD VSS sg13g2_decap_8
XDEC756 VDD VSS sg13g2_decap_8
XDEC757 VDD VSS sg13g2_decap_8
XDEC758 VDD VSS sg13g2_decap_8
XDEC759 VDD VSS sg13g2_decap_8
XDEC760 VDD VSS sg13g2_decap_8
XDEC761 VDD VSS sg13g2_decap_8
XDEC762 VDD VSS sg13g2_decap_8
XDEC763 VDD VSS sg13g2_decap_8
XDEC764 VDD VSS sg13g2_decap_8
XDEC765 VDD VSS sg13g2_decap_8
XDEC766 VDD VSS sg13g2_decap_8
XDEC767 VDD VSS sg13g2_decap_8
XDEC768 VDD VSS sg13g2_decap_8
XDEC769 VDD VSS sg13g2_decap_8
XDEC770 VDD VSS sg13g2_decap_8
XDEC771 VDD VSS sg13g2_decap_8
XDEC772 VDD VSS sg13g2_decap_8
XDEC773 VDD VSS sg13g2_decap_8
XDEC774 VDD VSS sg13g2_decap_8
XDEC775 VDD VSS sg13g2_decap_8
XDEC776 VDD VSS sg13g2_decap_8
XDEC777 VDD VSS sg13g2_decap_8
XDEC778 VDD VSS sg13g2_decap_8
XDEC779 VDD VSS sg13g2_decap_8
XDEC780 VDD VSS sg13g2_decap_8
XDEC781 VDD VSS sg13g2_decap_8
XDEC782 VDD VSS sg13g2_decap_8
XDEC783 VDD VSS sg13g2_decap_8
XDEC784 VDD VSS sg13g2_decap_8
XDEC785 VDD VSS sg13g2_decap_8
XDEC786 VDD VSS sg13g2_decap_8
XDEC787 VDD VSS sg13g2_decap_8
XDEC788 VDD VSS sg13g2_decap_8
XDEC789 VDD VSS sg13g2_decap_8
XDEC790 VDD VSS sg13g2_decap_8
XDEC791 VDD VSS sg13g2_decap_8
XDEC792 VDD VSS sg13g2_decap_8
XDEC793 VDD VSS sg13g2_decap_8
XDEC794 VDD VSS sg13g2_decap_8
XDEC795 VDD VSS sg13g2_decap_8
XDEC796 VDD VSS sg13g2_decap_8
XDEC797 VDD VSS sg13g2_decap_8
XDEC798 VDD VSS sg13g2_decap_8
XDEC799 VDD VSS sg13g2_decap_8
XDEC800 VDD VSS sg13g2_decap_8
XDEC801 VDD VSS sg13g2_decap_8
XDEC802 VDD VSS sg13g2_decap_8
XDEC803 VDD VSS sg13g2_decap_8
XDEC804 VDD VSS sg13g2_decap_8
XDEC805 VDD VSS sg13g2_decap_8
XDEC806 VDD VSS sg13g2_decap_8
XDEC807 VDD VSS sg13g2_decap_8
XDEC808 VDD VSS sg13g2_decap_8
XDEC809 VDD VSS sg13g2_decap_8
XDEC810 VDD VSS sg13g2_decap_8
XDEC811 VDD VSS sg13g2_decap_8
XDEC812 VDD VSS sg13g2_decap_8
XDEC813 VDD VSS sg13g2_decap_8
XDEC814 VDD VSS sg13g2_decap_8
XDEC815 VDD VSS sg13g2_decap_8
XDEC816 VDD VSS sg13g2_decap_8
XDEC817 VDD VSS sg13g2_decap_8
XDEC818 VDD VSS sg13g2_decap_8
XDEC819 VDD VSS sg13g2_decap_8
XDEC820 VDD VSS sg13g2_decap_8
XDEC821 VDD VSS sg13g2_decap_8
XDEC822 VDD VSS sg13g2_decap_8
XDEC823 VDD VSS sg13g2_decap_8
XDEC824 VDD VSS sg13g2_decap_8
XDEC825 VDD VSS sg13g2_decap_8
XDEC826 VDD VSS sg13g2_decap_8
XDEC827 VDD VSS sg13g2_decap_8
XDEC828 VDD VSS sg13g2_decap_8
XDEC829 VDD VSS sg13g2_decap_8
XDEC830 VDD VSS sg13g2_decap_8
XDEC831 VDD VSS sg13g2_decap_8
XDEC832 VDD VSS sg13g2_decap_8
XDEC833 VDD VSS sg13g2_decap_8
XDEC834 VDD VSS sg13g2_decap_8
XDEC835 VDD VSS sg13g2_decap_8
XDEC836 VDD VSS sg13g2_decap_8
XDEC837 VDD VSS sg13g2_decap_8
XDEC838 VDD VSS sg13g2_decap_8
XDEC839 VDD VSS sg13g2_decap_8
XDEC840 VDD VSS sg13g2_decap_8
XDEC841 VDD VSS sg13g2_decap_8
XDEC842 VDD VSS sg13g2_decap_8
XDEC843 VDD VSS sg13g2_decap_8
XDEC844 VDD VSS sg13g2_decap_8
XDEC845 VDD VSS sg13g2_decap_8
XDEC846 VDD VSS sg13g2_decap_8
XDEC847 VDD VSS sg13g2_decap_8
XDEC848 VDD VSS sg13g2_decap_8
XDEC849 VDD VSS sg13g2_decap_8
XDEC850 VDD VSS sg13g2_decap_8
XDEC851 VDD VSS sg13g2_decap_8
XDEC852 VDD VSS sg13g2_decap_8
XDEC853 VDD VSS sg13g2_decap_8
XDEC854 VDD VSS sg13g2_decap_8
XDEC855 VDD VSS sg13g2_decap_8
XDEC856 VDD VSS sg13g2_decap_8
XDEC857 VDD VSS sg13g2_decap_8
XDEC858 VDD VSS sg13g2_decap_8
XDEC859 VDD VSS sg13g2_decap_8
XDEC860 VDD VSS sg13g2_decap_8
XDEC861 VDD VSS sg13g2_decap_8
XDEC862 VDD VSS sg13g2_decap_8
XDEC863 VDD VSS sg13g2_decap_8
XDEC864 VDD VSS sg13g2_decap_8
XDEC865 VDD VSS sg13g2_decap_8
XDEC866 VDD VSS sg13g2_decap_8
XDEC867 VDD VSS sg13g2_decap_8
XDEC868 VDD VSS sg13g2_decap_8
XDEC869 VDD VSS sg13g2_decap_8
XDEC870 VDD VSS sg13g2_decap_8
XDEC871 VDD VSS sg13g2_decap_8
XDEC872 VDD VSS sg13g2_decap_8
XDEC873 VDD VSS sg13g2_decap_8
XDEC874 VDD VSS sg13g2_decap_8
XDEC875 VDD VSS sg13g2_decap_8
XDEC876 VDD VSS sg13g2_decap_8
XDEC877 VDD VSS sg13g2_decap_8
XDEC878 VDD VSS sg13g2_decap_8
XDEC879 VDD VSS sg13g2_decap_8
XDEC880 VDD VSS sg13g2_decap_8
XDEC881 VDD VSS sg13g2_decap_8
XDEC882 VDD VSS sg13g2_decap_8
XDEC883 VDD VSS sg13g2_decap_8
XDEC884 VDD VSS sg13g2_decap_8
XDEC885 VDD VSS sg13g2_decap_8
XDEC886 VDD VSS sg13g2_decap_8
XDEC887 VDD VSS sg13g2_decap_8
XDEC888 VDD VSS sg13g2_decap_8
XDEC889 VDD VSS sg13g2_decap_8
XDEC890 VDD VSS sg13g2_decap_8
XDEC891 VDD VSS sg13g2_decap_8
XDEC892 VDD VSS sg13g2_decap_8
XDEC893 VDD VSS sg13g2_decap_8
XDEC894 VDD VSS sg13g2_decap_8
XDEC895 VDD VSS sg13g2_decap_8
XDEC896 VDD VSS sg13g2_decap_8
XDEC897 VDD VSS sg13g2_decap_8
XDEC898 VDD VSS sg13g2_decap_8
XDEC899 VDD VSS sg13g2_decap_8
XDEC900 VDD VSS sg13g2_decap_8
XDEC901 VDD VSS sg13g2_decap_8
XDEC902 VDD VSS sg13g2_decap_8
XDEC903 VDD VSS sg13g2_decap_8
XDEC904 VDD VSS sg13g2_decap_8
XDEC905 VDD VSS sg13g2_decap_8
XDEC906 VDD VSS sg13g2_decap_8
XDEC907 VDD VSS sg13g2_decap_8
XDEC908 VDD VSS sg13g2_decap_8
XDEC909 VDD VSS sg13g2_decap_8
XDEC910 VDD VSS sg13g2_decap_8
XDEC911 VDD VSS sg13g2_decap_8
XDEC912 VDD VSS sg13g2_decap_8
XDEC913 VDD VSS sg13g2_decap_8
XDEC914 VDD VSS sg13g2_decap_8
XDEC915 VDD VSS sg13g2_decap_8
XDEC916 VDD VSS sg13g2_decap_8
XDEC917 VDD VSS sg13g2_decap_8
XDEC918 VDD VSS sg13g2_decap_8
XDEC919 VDD VSS sg13g2_decap_8
XDEC920 VDD VSS sg13g2_decap_8
XDEC921 VDD VSS sg13g2_decap_8
XDEC922 VDD VSS sg13g2_decap_8
XDEC923 VDD VSS sg13g2_decap_8
XDEC924 VDD VSS sg13g2_decap_8
XDEC925 VDD VSS sg13g2_decap_8
XDEC926 VDD VSS sg13g2_decap_8
XDEC927 VDD VSS sg13g2_decap_8
XDEC928 VDD VSS sg13g2_decap_8
XDEC929 VDD VSS sg13g2_decap_8
XDEC930 VDD VSS sg13g2_decap_8
XDEC931 VDD VSS sg13g2_decap_8
XDEC932 VDD VSS sg13g2_decap_8
XDEC933 VDD VSS sg13g2_decap_8
XDEC934 VDD VSS sg13g2_decap_8
XDEC935 VDD VSS sg13g2_decap_8
XDEC936 VDD VSS sg13g2_decap_8
XDEC937 VDD VSS sg13g2_decap_8
XDEC938 VDD VSS sg13g2_decap_8
XDEC939 VDD VSS sg13g2_decap_8
XDEC940 VDD VSS sg13g2_decap_8
XDEC941 VDD VSS sg13g2_decap_8
XDEC942 VDD VSS sg13g2_decap_8
XDEC943 VDD VSS sg13g2_decap_8
XDEC944 VDD VSS sg13g2_decap_8
XDEC945 VDD VSS sg13g2_decap_8
XDEC946 VDD VSS sg13g2_decap_8
XDEC947 VDD VSS sg13g2_decap_8
XDEC948 VDD VSS sg13g2_decap_8
XDEC949 VDD VSS sg13g2_decap_8
XDEC950 VDD VSS sg13g2_decap_8
XDEC951 VDD VSS sg13g2_decap_8
XDEC952 VDD VSS sg13g2_decap_8
XDEC953 VDD VSS sg13g2_decap_8
XDEC954 VDD VSS sg13g2_decap_8
XDEC955 VDD VSS sg13g2_decap_8
XDEC956 VDD VSS sg13g2_decap_8
XDEC957 VDD VSS sg13g2_decap_8
XDEC958 VDD VSS sg13g2_decap_8
XDEC959 VDD VSS sg13g2_decap_8
XDEC960 VDD VSS sg13g2_decap_8
XDEC961 VDD VSS sg13g2_decap_8
XDEC962 VDD VSS sg13g2_decap_8
XDEC963 VDD VSS sg13g2_decap_8
XDEC964 VDD VSS sg13g2_decap_8
XDEC965 VDD VSS sg13g2_decap_8
XDEC966 VDD VSS sg13g2_decap_8
XDEC967 VDD VSS sg13g2_decap_8
XDEC968 VDD VSS sg13g2_decap_8
XDEC969 VDD VSS sg13g2_decap_8
XDEC970 VDD VSS sg13g2_decap_8
XDEC971 VDD VSS sg13g2_decap_8
XDEC972 VDD VSS sg13g2_decap_8
XDEC973 VDD VSS sg13g2_decap_8
XDEC974 VDD VSS sg13g2_decap_8
XDEC975 VDD VSS sg13g2_decap_8
XDEC976 VDD VSS sg13g2_decap_8
XDEC977 VDD VSS sg13g2_decap_8
XDEC978 VDD VSS sg13g2_decap_8
XDEC979 VDD VSS sg13g2_decap_8
XDEC980 VDD VSS sg13g2_decap_8
XDEC981 VDD VSS sg13g2_decap_8
XDEC982 VDD VSS sg13g2_decap_8
XDEC983 VDD VSS sg13g2_decap_8
XDEC984 VDD VSS sg13g2_decap_8
XDEC985 VDD VSS sg13g2_decap_8
XDEC986 VDD VSS sg13g2_decap_8
XDEC987 VDD VSS sg13g2_decap_8
XDEC988 VDD VSS sg13g2_decap_8
XDEC989 VDD VSS sg13g2_decap_8
XDEC990 VDD VSS sg13g2_decap_8
XDEC991 VDD VSS sg13g2_decap_8
XDEC992 VDD VSS sg13g2_decap_8
XDEC993 VDD VSS sg13g2_decap_8
XDEC994 VDD VSS sg13g2_decap_8
XDEC995 VDD VSS sg13g2_decap_8
XDEC996 VDD VSS sg13g2_decap_8
XDEC997 VDD VSS sg13g2_decap_8
XDEC998 VDD VSS sg13g2_decap_8
XDEC999 VDD VSS sg13g2_decap_8
XDEC1000 VDD VSS sg13g2_decap_8
XDEC1001 VDD VSS sg13g2_decap_8
XDEC1002 VDD VSS sg13g2_decap_8
XDEC1003 VDD VSS sg13g2_decap_8
XDEC1004 VDD VSS sg13g2_decap_8
XDEC1005 VDD VSS sg13g2_decap_8
XDEC1006 VDD VSS sg13g2_decap_8
XDEC1007 VDD VSS sg13g2_decap_8
XDEC1008 VDD VSS sg13g2_decap_8
XDEC1009 VDD VSS sg13g2_decap_8
XDEC1010 VDD VSS sg13g2_decap_8
XDEC1011 VDD VSS sg13g2_decap_8
XDEC1012 VDD VSS sg13g2_decap_8
XDEC1013 VDD VSS sg13g2_decap_8
XDEC1014 VDD VSS sg13g2_decap_8
XDEC1015 VDD VSS sg13g2_decap_8
XDEC1016 VDD VSS sg13g2_decap_8
XDEC1017 VDD VSS sg13g2_decap_8
XDEC1018 VDD VSS sg13g2_decap_8
XDEC1019 VDD VSS sg13g2_decap_8
XDEC1020 VDD VSS sg13g2_decap_8
XDEC1021 VDD VSS sg13g2_decap_8
XDEC1022 VDD VSS sg13g2_decap_8
XDEC1023 VDD VSS sg13g2_decap_8
XDEC1024 VDD VSS sg13g2_decap_8
XDEC1025 VDD VSS sg13g2_decap_8
XDEC1026 VDD VSS sg13g2_decap_8
XDEC1027 VDD VSS sg13g2_decap_8
XDEC1028 VDD VSS sg13g2_decap_8
XDEC1029 VDD VSS sg13g2_decap_8
XDEC1030 VDD VSS sg13g2_decap_8
XDEC1031 VDD VSS sg13g2_decap_8
XDEC1032 VDD VSS sg13g2_decap_8
XDEC1033 VDD VSS sg13g2_decap_8
XDEC1034 VDD VSS sg13g2_decap_8
XDEC1035 VDD VSS sg13g2_decap_8
XDEC1036 VDD VSS sg13g2_decap_8
XDEC1037 VDD VSS sg13g2_decap_8
XDEC1038 VDD VSS sg13g2_decap_8
XDEC1039 VDD VSS sg13g2_decap_8
XDEC1040 VDD VSS sg13g2_decap_8
XDEC1041 VDD VSS sg13g2_decap_8
XDEC1042 VDD VSS sg13g2_decap_8
XDEC1043 VDD VSS sg13g2_decap_8
XDEC1044 VDD VSS sg13g2_decap_8
XDEC1045 VDD VSS sg13g2_decap_8
XDEC1046 VDD VSS sg13g2_decap_8
XDEC1047 VDD VSS sg13g2_decap_8
XDEC1048 VDD VSS sg13g2_decap_8
XDEC1049 VDD VSS sg13g2_decap_8
XDEC1050 VDD VSS sg13g2_decap_8
XDEC1051 VDD VSS sg13g2_decap_8
XDEC1052 VDD VSS sg13g2_decap_8
XDEC1053 VDD VSS sg13g2_decap_8
XDEC1054 VDD VSS sg13g2_decap_8
XDEC1055 VDD VSS sg13g2_decap_8
XDEC1056 VDD VSS sg13g2_decap_8
XDEC1057 VDD VSS sg13g2_decap_8
XDEC1058 VDD VSS sg13g2_decap_8
XDEC1059 VDD VSS sg13g2_decap_8
XDEC1060 VDD VSS sg13g2_decap_8
XDEC1061 VDD VSS sg13g2_decap_8
XDEC1062 VDD VSS sg13g2_decap_8
XDEC1063 VDD VSS sg13g2_decap_8
XDEC1064 VDD VSS sg13g2_decap_8
XDEC1065 VDD VSS sg13g2_decap_8
XDEC1066 VDD VSS sg13g2_decap_8
XDEC1067 VDD VSS sg13g2_decap_8
XDEC1068 VDD VSS sg13g2_decap_8
XDEC1069 VDD VSS sg13g2_decap_8
XDEC1070 VDD VSS sg13g2_decap_8
XDEC1071 VDD VSS sg13g2_decap_8
XDEC1072 VDD VSS sg13g2_decap_8
XDEC1073 VDD VSS sg13g2_decap_8
XDEC1074 VDD VSS sg13g2_decap_8
XDEC1075 VDD VSS sg13g2_decap_8
XDEC1076 VDD VSS sg13g2_decap_8
XDEC1077 VDD VSS sg13g2_decap_8
XDEC1078 VDD VSS sg13g2_decap_8
XDEC1079 VDD VSS sg13g2_decap_8
XDEC1080 VDD VSS sg13g2_decap_8
XDEC1081 VDD VSS sg13g2_decap_8
XDEC1082 VDD VSS sg13g2_decap_8
XDEC1083 VDD VSS sg13g2_decap_8
XDEC1084 VDD VSS sg13g2_decap_8
XDEC1085 VDD VSS sg13g2_decap_8
XDEC1086 VDD VSS sg13g2_decap_8
XDEC1087 VDD VSS sg13g2_decap_8
XDEC1088 VDD VSS sg13g2_decap_8
XDEC1089 VDD VSS sg13g2_decap_8
XDEC1090 VDD VSS sg13g2_decap_8
XDEC1091 VDD VSS sg13g2_decap_8
XDEC1092 VDD VSS sg13g2_decap_8
XDEC1093 VDD VSS sg13g2_decap_8
XDEC1094 VDD VSS sg13g2_decap_8
XDEC1095 VDD VSS sg13g2_decap_8
XDEC1096 VDD VSS sg13g2_decap_8
XDEC1097 VDD VSS sg13g2_decap_8
XDEC1098 VDD VSS sg13g2_decap_8
XDEC1099 VDD VSS sg13g2_decap_8
XDEC1100 VDD VSS sg13g2_decap_8
XDEC1101 VDD VSS sg13g2_decap_8
XDEC1102 VDD VSS sg13g2_decap_8
XDEC1103 VDD VSS sg13g2_decap_8
XDEC1104 VDD VSS sg13g2_decap_8
XDEC1105 VDD VSS sg13g2_decap_8
XDEC1106 VDD VSS sg13g2_decap_8
XDEC1107 VDD VSS sg13g2_decap_8
XDEC1108 VDD VSS sg13g2_decap_8
XDEC1109 VDD VSS sg13g2_decap_8
XDEC1110 VDD VSS sg13g2_decap_8
XDEC1111 VDD VSS sg13g2_decap_8
XDEC1112 VDD VSS sg13g2_decap_8
XDEC1113 VDD VSS sg13g2_decap_8
XDEC1114 VDD VSS sg13g2_decap_8
XDEC1115 VDD VSS sg13g2_decap_8
XDEC1116 VDD VSS sg13g2_decap_8
XDEC1117 VDD VSS sg13g2_decap_8
XDEC1118 VDD VSS sg13g2_decap_8
XDEC1119 VDD VSS sg13g2_decap_8
XDEC1120 VDD VSS sg13g2_decap_8
XDEC1121 VDD VSS sg13g2_decap_8
XDEC1122 VDD VSS sg13g2_decap_8
XDEC1123 VDD VSS sg13g2_decap_8
XDEC1124 VDD VSS sg13g2_decap_8
XDEC1125 VDD VSS sg13g2_decap_8
XDEC1126 VDD VSS sg13g2_decap_8
XDEC1127 VDD VSS sg13g2_decap_8
XDEC1128 VDD VSS sg13g2_decap_8
XDEC1129 VDD VSS sg13g2_decap_8
XDEC1130 VDD VSS sg13g2_decap_8
XDEC1131 VDD VSS sg13g2_decap_8
XDEC1132 VDD VSS sg13g2_decap_8
XDEC1133 VDD VSS sg13g2_decap_8
XDEC1134 VDD VSS sg13g2_decap_8
XDEC1135 VDD VSS sg13g2_decap_8
XDEC1136 VDD VSS sg13g2_decap_8
XDEC1137 VDD VSS sg13g2_decap_8
XDEC1138 VDD VSS sg13g2_decap_8
XDEC1139 VDD VSS sg13g2_decap_8
XDEC1140 VDD VSS sg13g2_decap_8
XDEC1141 VDD VSS sg13g2_decap_8
XDEC1142 VDD VSS sg13g2_decap_8
XDEC1143 VDD VSS sg13g2_decap_8
XDEC1144 VDD VSS sg13g2_decap_8
XDEC1145 VDD VSS sg13g2_decap_8
XDEC1146 VDD VSS sg13g2_decap_8
XDEC1147 VDD VSS sg13g2_decap_8
XDEC1148 VDD VSS sg13g2_decap_8
XDEC1149 VDD VSS sg13g2_decap_8
XDEC1150 VDD VSS sg13g2_decap_8
XDEC1151 VDD VSS sg13g2_decap_8
XDEC1152 VDD VSS sg13g2_decap_8
XDEC1153 VDD VSS sg13g2_decap_8
XDEC1154 VDD VSS sg13g2_decap_8
XDEC1155 VDD VSS sg13g2_decap_8
XDEC1156 VDD VSS sg13g2_decap_8
XDEC1157 VDD VSS sg13g2_decap_8
XDEC1158 VDD VSS sg13g2_decap_8
XDEC1159 VDD VSS sg13g2_decap_8
XDEC1160 VDD VSS sg13g2_decap_8
XDEC1161 VDD VSS sg13g2_decap_8
XDEC1162 VDD VSS sg13g2_decap_8
XDEC1163 VDD VSS sg13g2_decap_8
XDEC1164 VDD VSS sg13g2_decap_8
XDEC1165 VDD VSS sg13g2_decap_8
XDEC1166 VDD VSS sg13g2_decap_8
XDEC1167 VDD VSS sg13g2_decap_8
XDEC1168 VDD VSS sg13g2_decap_8
XDEC1169 VDD VSS sg13g2_decap_8
XDEC1170 VDD VSS sg13g2_decap_8
XDEC1171 VDD VSS sg13g2_decap_8
XDEC1172 VDD VSS sg13g2_decap_8
XDEC1173 VDD VSS sg13g2_decap_8
XDEC1174 VDD VSS sg13g2_decap_8
XDEC1175 VDD VSS sg13g2_decap_8
XDEC1176 VDD VSS sg13g2_decap_8
XDEC1177 VDD VSS sg13g2_decap_8
XDEC1178 VDD VSS sg13g2_decap_8
XDEC1179 VDD VSS sg13g2_decap_8
XDEC1180 VDD VSS sg13g2_decap_8
XDEC1181 VDD VSS sg13g2_decap_8
XDEC1182 VDD VSS sg13g2_decap_8
XDEC1183 VDD VSS sg13g2_decap_8
XDEC1184 VDD VSS sg13g2_decap_8
XDEC1185 VDD VSS sg13g2_decap_8
XDEC1186 VDD VSS sg13g2_decap_8
XDEC1187 VDD VSS sg13g2_decap_8
XDEC1188 VDD VSS sg13g2_decap_8
XDEC1189 VDD VSS sg13g2_decap_8
XDEC1190 VDD VSS sg13g2_decap_8
XDEC1191 VDD VSS sg13g2_decap_8
XDEC1192 VDD VSS sg13g2_decap_8
XDEC1193 VDD VSS sg13g2_decap_8
XDEC1194 VDD VSS sg13g2_decap_8
XDEC1195 VDD VSS sg13g2_decap_8
XDEC1196 VDD VSS sg13g2_decap_8
XDEC1197 VDD VSS sg13g2_decap_8
XDEC1198 VDD VSS sg13g2_decap_8
XDEC1199 VDD VSS sg13g2_decap_8
XDEC1200 VDD VSS sg13g2_decap_8
XDEC1201 VDD VSS sg13g2_decap_8
XDEC1202 VDD VSS sg13g2_decap_8
XDEC1203 VDD VSS sg13g2_decap_8
XDEC1204 VDD VSS sg13g2_decap_8
XDEC1205 VDD VSS sg13g2_decap_8
XDEC1206 VDD VSS sg13g2_decap_8
XDEC1207 VDD VSS sg13g2_decap_8
XDEC1208 VDD VSS sg13g2_decap_8
XDEC1209 VDD VSS sg13g2_decap_8
XDEC1210 VDD VSS sg13g2_decap_8
XDEC1211 VDD VSS sg13g2_decap_8
XDEC1212 VDD VSS sg13g2_decap_8
XDEC1213 VDD VSS sg13g2_decap_8
XDEC1214 VDD VSS sg13g2_decap_8
XDEC1215 VDD VSS sg13g2_decap_8
XDEC1216 VDD VSS sg13g2_decap_8
XDEC1217 VDD VSS sg13g2_decap_8
XDEC1218 VDD VSS sg13g2_decap_8
XDEC1219 VDD VSS sg13g2_decap_8
XDEC1220 VDD VSS sg13g2_decap_8
XDEC1221 VDD VSS sg13g2_decap_8
XDEC1222 VDD VSS sg13g2_decap_8
XDEC1223 VDD VSS sg13g2_decap_8
XDEC1224 VDD VSS sg13g2_decap_8
XDEC1225 VDD VSS sg13g2_decap_8
XDEC1226 VDD VSS sg13g2_decap_8
XDEC1227 VDD VSS sg13g2_decap_8
XDEC1228 VDD VSS sg13g2_decap_8
XDEC1229 VDD VSS sg13g2_decap_8
XDEC1230 VDD VSS sg13g2_decap_8
XDEC1231 VDD VSS sg13g2_decap_8
XDEC1232 VDD VSS sg13g2_decap_8
XDEC1233 VDD VSS sg13g2_decap_8
XDEC1234 VDD VSS sg13g2_decap_8
XDEC1235 VDD VSS sg13g2_decap_8
XDEC1236 VDD VSS sg13g2_decap_8
XDEC1237 VDD VSS sg13g2_decap_8
XDEC1238 VDD VSS sg13g2_decap_8
XDEC1239 VDD VSS sg13g2_decap_8
XDEC1240 VDD VSS sg13g2_decap_8
XDEC1241 VDD VSS sg13g2_decap_8
XDEC1242 VDD VSS sg13g2_decap_8
XDEC1243 VDD VSS sg13g2_decap_8
XDEC1244 VDD VSS sg13g2_decap_8
XDEC1245 VDD VSS sg13g2_decap_8
XDEC1246 VDD VSS sg13g2_decap_8
XDEC1247 VDD VSS sg13g2_decap_8
XDEC1248 VDD VSS sg13g2_decap_8
XDEC1249 VDD VSS sg13g2_decap_8
XDEC1250 VDD VSS sg13g2_decap_8
XDEC1251 VDD VSS sg13g2_decap_8
XDEC1252 VDD VSS sg13g2_decap_8
XDEC1253 VDD VSS sg13g2_decap_8
XDEC1254 VDD VSS sg13g2_decap_8
XDEC1255 VDD VSS sg13g2_decap_8
XDEC1256 VDD VSS sg13g2_decap_8
XDEC1257 VDD VSS sg13g2_decap_8
XDEC1258 VDD VSS sg13g2_decap_8
XDEC1259 VDD VSS sg13g2_decap_8
XDEC1260 VDD VSS sg13g2_decap_8
XDEC1261 VDD VSS sg13g2_decap_8
XDEC1262 VDD VSS sg13g2_decap_8
XDEC1263 VDD VSS sg13g2_decap_8
XDEC1264 VDD VSS sg13g2_decap_8
XDEC1265 VDD VSS sg13g2_decap_8
XDEC1266 VDD VSS sg13g2_decap_8
XDEC1267 VDD VSS sg13g2_decap_8
XDEC1268 VDD VSS sg13g2_decap_8
XDEC1269 VDD VSS sg13g2_decap_8
XDEC1270 VDD VSS sg13g2_decap_8
XDEC1271 VDD VSS sg13g2_decap_8
XDEC1272 VDD VSS sg13g2_decap_8
XDEC1273 VDD VSS sg13g2_decap_8
XDEC1274 VDD VSS sg13g2_decap_8
XDEC1275 VDD VSS sg13g2_decap_8
XDEC1276 VDD VSS sg13g2_decap_8
XDEC1277 VDD VSS sg13g2_decap_8
XDEC1278 VDD VSS sg13g2_decap_8
XDEC1279 VDD VSS sg13g2_decap_8
XDEC1280 VDD VSS sg13g2_decap_8
XDEC1281 VDD VSS sg13g2_decap_8
XDEC1282 VDD VSS sg13g2_decap_8
XDEC1283 VDD VSS sg13g2_decap_8
XDEC1284 VDD VSS sg13g2_decap_8
XDEC1285 VDD VSS sg13g2_decap_8
XDEC1286 VDD VSS sg13g2_decap_8
XDEC1287 VDD VSS sg13g2_decap_8
XDEC1288 VDD VSS sg13g2_decap_8
XDEC1289 VDD VSS sg13g2_decap_8
XDEC1290 VDD VSS sg13g2_decap_8
XDEC1291 VDD VSS sg13g2_decap_8
XDEC1292 VDD VSS sg13g2_decap_8
XDEC1293 VDD VSS sg13g2_decap_8
XDEC1294 VDD VSS sg13g2_decap_8
XDEC1295 VDD VSS sg13g2_decap_8
XDEC1296 VDD VSS sg13g2_decap_8
XDEC1297 VDD VSS sg13g2_decap_8
XDEC1298 VDD VSS sg13g2_decap_8
XDEC1299 VDD VSS sg13g2_decap_8
XDEC1300 VDD VSS sg13g2_decap_8
XDEC1301 VDD VSS sg13g2_decap_8
XDEC1302 VDD VSS sg13g2_decap_8
XDEC1303 VDD VSS sg13g2_decap_8
XDEC1304 VDD VSS sg13g2_decap_8
XDEC1305 VDD VSS sg13g2_decap_8
XDEC1306 VDD VSS sg13g2_decap_8
XDEC1307 VDD VSS sg13g2_decap_8
XDEC1308 VDD VSS sg13g2_decap_8
XDEC1309 VDD VSS sg13g2_decap_8
XDEC1310 VDD VSS sg13g2_decap_8
XDEC1311 VDD VSS sg13g2_decap_8
XDEC1312 VDD VSS sg13g2_decap_8
XDEC1313 VDD VSS sg13g2_decap_8
XDEC1314 VDD VSS sg13g2_decap_8
XDEC1315 VDD VSS sg13g2_decap_8
XDEC1316 VDD VSS sg13g2_decap_8
XDEC1317 VDD VSS sg13g2_decap_8
XDEC1318 VDD VSS sg13g2_decap_8
XDEC1319 VDD VSS sg13g2_decap_8
XDEC1320 VDD VSS sg13g2_decap_8
XDEC1321 VDD VSS sg13g2_decap_8
XDEC1322 VDD VSS sg13g2_decap_8
XDEC1323 VDD VSS sg13g2_decap_8
XDEC1324 VDD VSS sg13g2_decap_8
XDEC1325 VDD VSS sg13g2_decap_8
XDEC1326 VDD VSS sg13g2_decap_8
XDEC1327 VDD VSS sg13g2_decap_8
XDEC1328 VDD VSS sg13g2_decap_8
XDEC1329 VDD VSS sg13g2_decap_8
XDEC1330 VDD VSS sg13g2_decap_8
XDEC1331 VDD VSS sg13g2_decap_8
XDEC1332 VDD VSS sg13g2_decap_8
XDEC1333 VDD VSS sg13g2_decap_8
XDEC1334 VDD VSS sg13g2_decap_8
XDEC1335 VDD VSS sg13g2_decap_8
XDEC1336 VDD VSS sg13g2_decap_8
XDEC1337 VDD VSS sg13g2_decap_8
XDEC1338 VDD VSS sg13g2_decap_8
XDEC1339 VDD VSS sg13g2_decap_8
XDEC1340 VDD VSS sg13g2_decap_8
XDEC1341 VDD VSS sg13g2_decap_8
XDEC1342 VDD VSS sg13g2_decap_8
XDEC1343 VDD VSS sg13g2_decap_8
XDEC1344 VDD VSS sg13g2_decap_8
XDEC1345 VDD VSS sg13g2_decap_8
XDEC1346 VDD VSS sg13g2_decap_8
XDEC1347 VDD VSS sg13g2_decap_8
XDEC1348 VDD VSS sg13g2_decap_8
XDEC1349 VDD VSS sg13g2_decap_8
XDEC1350 VDD VSS sg13g2_decap_8
XDEC1351 VDD VSS sg13g2_decap_8
XDEC1352 VDD VSS sg13g2_decap_8
XDEC1353 VDD VSS sg13g2_decap_8
XDEC1354 VDD VSS sg13g2_decap_8
XDEC1355 VDD VSS sg13g2_decap_8
XDEC1356 VDD VSS sg13g2_decap_8
XDEC1357 VDD VSS sg13g2_decap_8
XDEC1358 VDD VSS sg13g2_decap_8
XDEC1359 VDD VSS sg13g2_decap_8
XDEC1360 VDD VSS sg13g2_decap_8
XDEC1361 VDD VSS sg13g2_decap_8
XDEC1362 VDD VSS sg13g2_decap_8
XDEC1363 VDD VSS sg13g2_decap_8
XDEC1364 VDD VSS sg13g2_decap_8
XDEC1365 VDD VSS sg13g2_decap_8
XDEC1366 VDD VSS sg13g2_decap_8
XDEC1367 VDD VSS sg13g2_decap_8
XDEC1368 VDD VSS sg13g2_decap_8
XDEC1369 VDD VSS sg13g2_decap_8
XDEC1370 VDD VSS sg13g2_decap_8
XDEC1371 VDD VSS sg13g2_decap_8
XDEC1372 VDD VSS sg13g2_decap_8
XDEC1373 VDD VSS sg13g2_decap_8
XDEC1374 VDD VSS sg13g2_decap_8
XDEC1375 VDD VSS sg13g2_decap_8
XDEC1376 VDD VSS sg13g2_decap_8
XDEC1377 VDD VSS sg13g2_decap_8
XDEC1378 VDD VSS sg13g2_decap_8
XDEC1379 VDD VSS sg13g2_decap_8
XDEC1380 VDD VSS sg13g2_decap_8
XDEC1381 VDD VSS sg13g2_decap_8
XDEC1382 VDD VSS sg13g2_decap_8
XDEC1383 VDD VSS sg13g2_decap_8
XDEC1384 VDD VSS sg13g2_decap_8
XDEC1385 VDD VSS sg13g2_decap_8
XDEC1386 VDD VSS sg13g2_decap_8
XDEC1387 VDD VSS sg13g2_decap_8
XDEC1388 VDD VSS sg13g2_decap_8
XDEC1389 VDD VSS sg13g2_decap_8
XDEC1390 VDD VSS sg13g2_decap_8
XDEC1391 VDD VSS sg13g2_decap_8
XDEC1392 VDD VSS sg13g2_decap_8
XDEC1393 VDD VSS sg13g2_decap_8
XDEC1394 VDD VSS sg13g2_decap_8
XDEC1395 VDD VSS sg13g2_decap_8
XDEC1396 VDD VSS sg13g2_decap_8
XDEC1397 VDD VSS sg13g2_decap_8
XDEC1398 VDD VSS sg13g2_decap_8
XDEC1399 VDD VSS sg13g2_decap_8
XDEC1400 VDD VSS sg13g2_decap_8
XDEC1401 VDD VSS sg13g2_decap_8
XDEC1402 VDD VSS sg13g2_decap_8
XDEC1403 VDD VSS sg13g2_decap_8
XDEC1404 VDD VSS sg13g2_decap_8
XDEC1405 VDD VSS sg13g2_decap_8
XDEC1406 VDD VSS sg13g2_decap_8
XDEC1407 VDD VSS sg13g2_decap_8
XDEC1408 VDD VSS sg13g2_decap_8
XDEC1409 VDD VSS sg13g2_decap_8
XDEC1410 VDD VSS sg13g2_decap_8
XDEC1411 VDD VSS sg13g2_decap_8
XDEC1412 VDD VSS sg13g2_decap_8
XDEC1413 VDD VSS sg13g2_decap_8
XDEC1414 VDD VSS sg13g2_decap_8
XDEC1415 VDD VSS sg13g2_decap_8
XDEC1416 VDD VSS sg13g2_decap_8
XDEC1417 VDD VSS sg13g2_decap_8
XDEC1418 VDD VSS sg13g2_decap_8
XDEC1419 VDD VSS sg13g2_decap_8
XDEC1420 VDD VSS sg13g2_decap_8
XDEC1421 VDD VSS sg13g2_decap_8
XDEC1422 VDD VSS sg13g2_decap_8
XDEC1423 VDD VSS sg13g2_decap_8
XDEC1424 VDD VSS sg13g2_decap_8
XDEC1425 VDD VSS sg13g2_decap_8
XDEC1426 VDD VSS sg13g2_decap_8
XDEC1427 VDD VSS sg13g2_decap_8
XDEC1428 VDD VSS sg13g2_decap_8
XDEC1429 VDD VSS sg13g2_decap_8
XDEC1430 VDD VSS sg13g2_decap_8
XDEC1431 VDD VSS sg13g2_decap_8
XDEC1432 VDD VSS sg13g2_decap_8
XDEC1433 VDD VSS sg13g2_decap_8
XDEC1434 VDD VSS sg13g2_decap_8
XDEC1435 VDD VSS sg13g2_decap_8
XDEC1436 VDD VSS sg13g2_decap_8
XDEC1437 VDD VSS sg13g2_decap_8
XDEC1438 VDD VSS sg13g2_decap_8
XDEC1439 VDD VSS sg13g2_decap_8
XDEC1440 VDD VSS sg13g2_decap_8
XDEC1441 VDD VSS sg13g2_decap_8
XDEC1442 VDD VSS sg13g2_decap_8
XDEC1443 VDD VSS sg13g2_decap_8
XDEC1444 VDD VSS sg13g2_decap_8
XDEC1445 VDD VSS sg13g2_decap_8
XDEC1446 VDD VSS sg13g2_decap_8
XDEC1447 VDD VSS sg13g2_decap_8
XDEC1448 VDD VSS sg13g2_decap_8
XDEC1449 VDD VSS sg13g2_decap_8
XDEC1450 VDD VSS sg13g2_decap_8
XDEC1451 VDD VSS sg13g2_decap_8
XDEC1452 VDD VSS sg13g2_decap_8
XDEC1453 VDD VSS sg13g2_decap_8
XDEC1454 VDD VSS sg13g2_decap_8
XDEC1455 VDD VSS sg13g2_decap_8
XDEC1456 VDD VSS sg13g2_decap_8
XDEC1457 VDD VSS sg13g2_decap_8
XDEC1458 VDD VSS sg13g2_decap_8
XDEC1459 VDD VSS sg13g2_decap_8
XDEC1460 VDD VSS sg13g2_decap_8
XDEC1461 VDD VSS sg13g2_decap_8
XDEC1462 VDD VSS sg13g2_decap_8
XDEC1463 VDD VSS sg13g2_decap_8
XDEC1464 VDD VSS sg13g2_decap_8
XDEC1465 VDD VSS sg13g2_decap_8
XDEC1466 VDD VSS sg13g2_decap_8
XDEC1467 VDD VSS sg13g2_decap_8
XDEC1468 VDD VSS sg13g2_decap_8
XDEC1469 VDD VSS sg13g2_decap_8
XDEC1470 VDD VSS sg13g2_decap_8
XDEC1471 VDD VSS sg13g2_decap_8
XDEC1472 VDD VSS sg13g2_decap_8
XDEC1473 VDD VSS sg13g2_decap_8
XDEC1474 VDD VSS sg13g2_decap_8
XDEC1475 VDD VSS sg13g2_decap_8
XDEC1476 VDD VSS sg13g2_decap_8
XDEC1477 VDD VSS sg13g2_decap_8
XDEC1478 VDD VSS sg13g2_decap_8
XDEC1479 VDD VSS sg13g2_decap_8
XDEC1480 VDD VSS sg13g2_decap_8
XDEC1481 VDD VSS sg13g2_decap_8
XDEC1482 VDD VSS sg13g2_decap_8
XDEC1483 VDD VSS sg13g2_decap_8
XDEC1484 VDD VSS sg13g2_decap_8
XDEC1485 VDD VSS sg13g2_decap_8
XDEC1486 VDD VSS sg13g2_decap_8
XDEC1487 VDD VSS sg13g2_decap_8
XDEC1488 VDD VSS sg13g2_decap_8
XDEC1489 VDD VSS sg13g2_decap_8
XDEC1490 VDD VSS sg13g2_decap_8
XDEC1491 VDD VSS sg13g2_decap_8
XDEC1492 VDD VSS sg13g2_decap_8
XDEC1493 VDD VSS sg13g2_decap_8
XDEC1494 VDD VSS sg13g2_decap_8
XDEC1495 VDD VSS sg13g2_decap_8
XDEC1496 VDD VSS sg13g2_decap_8
XDEC1497 VDD VSS sg13g2_decap_8
XDEC1498 VDD VSS sg13g2_decap_8
XDEC1499 VDD VSS sg13g2_decap_8
XDEC1500 VDD VSS sg13g2_decap_8
XDEC1501 VDD VSS sg13g2_decap_8
XDEC1502 VDD VSS sg13g2_decap_8
XDEC1503 VDD VSS sg13g2_decap_8
XDEC1504 VDD VSS sg13g2_decap_8
XDEC1505 VDD VSS sg13g2_decap_8
XDEC1506 VDD VSS sg13g2_decap_8
XDEC1507 VDD VSS sg13g2_decap_8
XDEC1508 VDD VSS sg13g2_decap_8
XDEC1509 VDD VSS sg13g2_decap_8
XDEC1510 VDD VSS sg13g2_decap_8
XDEC1511 VDD VSS sg13g2_decap_8
XDEC1512 VDD VSS sg13g2_decap_8
XDEC1513 VDD VSS sg13g2_decap_8
XDEC1514 VDD VSS sg13g2_decap_8
XDEC1515 VDD VSS sg13g2_decap_8
XDEC1516 VDD VSS sg13g2_decap_8
XDEC1517 VDD VSS sg13g2_decap_8
XDEC1518 VDD VSS sg13g2_decap_8
XDEC1519 VDD VSS sg13g2_decap_8
XDEC1520 VDD VSS sg13g2_decap_8
XDEC1521 VDD VSS sg13g2_decap_8
XDEC1522 VDD VSS sg13g2_decap_8
XDEC1523 VDD VSS sg13g2_decap_8
XDEC1524 VDD VSS sg13g2_decap_8
XDEC1525 VDD VSS sg13g2_decap_8
XDEC1526 VDD VSS sg13g2_decap_8
XDEC1527 VDD VSS sg13g2_decap_8
XDEC1528 VDD VSS sg13g2_decap_8
XDEC1529 VDD VSS sg13g2_decap_8
XDEC1530 VDD VSS sg13g2_decap_8
XDEC1531 VDD VSS sg13g2_decap_8
XDEC1532 VDD VSS sg13g2_decap_8
XDEC1533 VDD VSS sg13g2_decap_8
XDEC1534 VDD VSS sg13g2_decap_8
XDEC1535 VDD VSS sg13g2_decap_8
XDEC1536 VDD VSS sg13g2_decap_8
XDEC1537 VDD VSS sg13g2_decap_8
XDEC1538 VDD VSS sg13g2_decap_8
XDEC1539 VDD VSS sg13g2_decap_8
XDEC1540 VDD VSS sg13g2_decap_8
XDEC1541 VDD VSS sg13g2_decap_8
XDEC1542 VDD VSS sg13g2_decap_8
XDEC1543 VDD VSS sg13g2_decap_8
XDEC1544 VDD VSS sg13g2_decap_8
XDEC1545 VDD VSS sg13g2_decap_8
XDEC1546 VDD VSS sg13g2_decap_8
XDEC1547 VDD VSS sg13g2_decap_8
XDEC1548 VDD VSS sg13g2_decap_8
XDEC1549 VDD VSS sg13g2_decap_8
XDEC1550 VDD VSS sg13g2_decap_8
XDEC1551 VDD VSS sg13g2_decap_8
XDEC1552 VDD VSS sg13g2_decap_8
XDEC1553 VDD VSS sg13g2_decap_8
XDEC1554 VDD VSS sg13g2_decap_8
XDEC1555 VDD VSS sg13g2_decap_8
XDEC1556 VDD VSS sg13g2_decap_8
XDEC1557 VDD VSS sg13g2_decap_8
XDEC1558 VDD VSS sg13g2_decap_8
XDEC1559 VDD VSS sg13g2_decap_8
XDEC1560 VDD VSS sg13g2_decap_8
XDEC1561 VDD VSS sg13g2_decap_8
XDEC1562 VDD VSS sg13g2_decap_8
XDEC1563 VDD VSS sg13g2_decap_8
XDEC1564 VDD VSS sg13g2_decap_8
XDEC1565 VDD VSS sg13g2_decap_8
XDEC1566 VDD VSS sg13g2_decap_8
XDEC1567 VDD VSS sg13g2_decap_8
XDEC1568 VDD VSS sg13g2_decap_8
XDEC1569 VDD VSS sg13g2_decap_8
XDEC1570 VDD VSS sg13g2_decap_8
XDEC1571 VDD VSS sg13g2_decap_8
XDEC1572 VDD VSS sg13g2_decap_8
XDEC1573 VDD VSS sg13g2_decap_8
XDEC1574 VDD VSS sg13g2_decap_8
XDEC1575 VDD VSS sg13g2_decap_8
XDEC1576 VDD VSS sg13g2_decap_8
XDEC1577 VDD VSS sg13g2_decap_8
XDEC1578 VDD VSS sg13g2_decap_8
XDEC1579 VDD VSS sg13g2_decap_8
XDEC1580 VDD VSS sg13g2_decap_8
XDEC1581 VDD VSS sg13g2_decap_8
XDEC1582 VDD VSS sg13g2_decap_8
XDEC1583 VDD VSS sg13g2_decap_8
XDEC1584 VDD VSS sg13g2_decap_8
XDEC1585 VDD VSS sg13g2_decap_8
XDEC1586 VDD VSS sg13g2_decap_8
XDEC1587 VDD VSS sg13g2_decap_8
XDEC1588 VDD VSS sg13g2_decap_8
XDEC1589 VDD VSS sg13g2_decap_8
XDEC1590 VDD VSS sg13g2_decap_8
XDEC1591 VDD VSS sg13g2_decap_8
XDEC1592 VDD VSS sg13g2_decap_8
XDEC1593 VDD VSS sg13g2_decap_8
XDEC1594 VDD VSS sg13g2_decap_8
XDEC1595 VDD VSS sg13g2_decap_8
XDEC1596 VDD VSS sg13g2_decap_8
XDEC1597 VDD VSS sg13g2_decap_8
XDEC1598 VDD VSS sg13g2_decap_8
XDEC1599 VDD VSS sg13g2_decap_8
XDEC1600 VDD VSS sg13g2_decap_8
XDEC1601 VDD VSS sg13g2_decap_8
XDEC1602 VDD VSS sg13g2_decap_8
XDEC1603 VDD VSS sg13g2_decap_8
XDEC1604 VDD VSS sg13g2_decap_8
XDEC1605 VDD VSS sg13g2_decap_8
XDEC1606 VDD VSS sg13g2_decap_8
XDEC1607 VDD VSS sg13g2_decap_8
XDEC1608 VDD VSS sg13g2_decap_8
XDEC1609 VDD VSS sg13g2_decap_8
XDEC1610 VDD VSS sg13g2_decap_8
XDEC1611 VDD VSS sg13g2_decap_8
XDEC1612 VDD VSS sg13g2_decap_8
XDEC1613 VDD VSS sg13g2_decap_8
XDEC1614 VDD VSS sg13g2_decap_8
XDEC1615 VDD VSS sg13g2_decap_8
XDEC1616 VDD VSS sg13g2_decap_8
XDEC1617 VDD VSS sg13g2_decap_8
XDEC1618 VDD VSS sg13g2_decap_8
XDEC1619 VDD VSS sg13g2_decap_8
XDEC1620 VDD VSS sg13g2_decap_8
XDEC1621 VDD VSS sg13g2_decap_8
XDEC1622 VDD VSS sg13g2_decap_8
XDEC1623 VDD VSS sg13g2_decap_8
XDEC1624 VDD VSS sg13g2_decap_8
XDEC1625 VDD VSS sg13g2_decap_8
XDEC1626 VDD VSS sg13g2_decap_8
XDEC1627 VDD VSS sg13g2_decap_8
XDEC1628 VDD VSS sg13g2_decap_8
XDEC1629 VDD VSS sg13g2_decap_8
XDEC1630 VDD VSS sg13g2_decap_8
XDEC1631 VDD VSS sg13g2_decap_8
XDEC1632 VDD VSS sg13g2_decap_8
XDEC1633 VDD VSS sg13g2_decap_8
XDEC1634 VDD VSS sg13g2_decap_8
XDEC1635 VDD VSS sg13g2_decap_8
XDEC1636 VDD VSS sg13g2_decap_8
XDEC1637 VDD VSS sg13g2_decap_8
XDEC1638 VDD VSS sg13g2_decap_8
XDEC1639 VDD VSS sg13g2_decap_8
XDEC1640 VDD VSS sg13g2_decap_8
XDEC1641 VDD VSS sg13g2_decap_8
XDEC1642 VDD VSS sg13g2_decap_8
XDEC1643 VDD VSS sg13g2_decap_8
XDEC1644 VDD VSS sg13g2_decap_8
XDEC1645 VDD VSS sg13g2_decap_8
XDEC1646 VDD VSS sg13g2_decap_8
XDEC1647 VDD VSS sg13g2_decap_8
XDEC1648 VDD VSS sg13g2_decap_8
XDEC1649 VDD VSS sg13g2_decap_8
XDEC1650 VDD VSS sg13g2_decap_8
XDEC1651 VDD VSS sg13g2_decap_8
XDEC1652 VDD VSS sg13g2_decap_8
XDEC1653 VDD VSS sg13g2_decap_8
XDEC1654 VDD VSS sg13g2_decap_8
XDEC1655 VDD VSS sg13g2_decap_8
XDEC1656 VDD VSS sg13g2_decap_8
XDEC1657 VDD VSS sg13g2_decap_8
XDEC1658 VDD VSS sg13g2_decap_8
XDEC1659 VDD VSS sg13g2_decap_8
XDEC1660 VDD VSS sg13g2_decap_8
XDEC1661 VDD VSS sg13g2_decap_8
XDEC1662 VDD VSS sg13g2_decap_8
XDEC1663 VDD VSS sg13g2_decap_8
XDEC1664 VDD VSS sg13g2_decap_8
XDEC1665 VDD VSS sg13g2_decap_8
XDEC1666 VDD VSS sg13g2_decap_8
XDEC1667 VDD VSS sg13g2_decap_8
XDEC1668 VDD VSS sg13g2_decap_8
XDEC1669 VDD VSS sg13g2_decap_8
XDEC1670 VDD VSS sg13g2_decap_8
XDEC1671 VDD VSS sg13g2_decap_8
XDEC1672 VDD VSS sg13g2_decap_8
XDEC1673 VDD VSS sg13g2_decap_8
XDEC1674 VDD VSS sg13g2_decap_8
XDEC1675 VDD VSS sg13g2_decap_8
XDEC1676 VDD VSS sg13g2_decap_8
XDEC1677 VDD VSS sg13g2_decap_8
XDEC1678 VDD VSS sg13g2_decap_8
XDEC1679 VDD VSS sg13g2_decap_8
XDEC1680 VDD VSS sg13g2_decap_8
XDEC1681 VDD VSS sg13g2_decap_8
XDEC1682 VDD VSS sg13g2_decap_8
XDEC1683 VDD VSS sg13g2_decap_8
XDEC1684 VDD VSS sg13g2_decap_8
XDEC1685 VDD VSS sg13g2_decap_8
XDEC1686 VDD VSS sg13g2_decap_8
XDEC1687 VDD VSS sg13g2_decap_8
XDEC1688 VDD VSS sg13g2_decap_8
XDEC1689 VDD VSS sg13g2_decap_8
XDEC1690 VDD VSS sg13g2_decap_8
XDEC1691 VDD VSS sg13g2_decap_8
XDEC1692 VDD VSS sg13g2_decap_8
XDEC1693 VDD VSS sg13g2_decap_8
XDEC1694 VDD VSS sg13g2_decap_8
XDEC1695 VDD VSS sg13g2_decap_8
XDEC1696 VDD VSS sg13g2_decap_8
XDEC1697 VDD VSS sg13g2_decap_8
XDEC1698 VDD VSS sg13g2_decap_8
XDEC1699 VDD VSS sg13g2_decap_8
XDEC1700 VDD VSS sg13g2_decap_8
XDEC1701 VDD VSS sg13g2_decap_8
XDEC1702 VDD VSS sg13g2_decap_8
XDEC1703 VDD VSS sg13g2_decap_8
XDEC1704 VDD VSS sg13g2_decap_8
XDEC1705 VDD VSS sg13g2_decap_8
XDEC1706 VDD VSS sg13g2_decap_8
XDEC1707 VDD VSS sg13g2_decap_8
XDEC1708 VDD VSS sg13g2_decap_8
XDEC1709 VDD VSS sg13g2_decap_8
XDEC1710 VDD VSS sg13g2_decap_8
XDEC1711 VDD VSS sg13g2_decap_8
XDEC1712 VDD VSS sg13g2_decap_8
XDEC1713 VDD VSS sg13g2_decap_8
XDEC1714 VDD VSS sg13g2_decap_8
XDEC1715 VDD VSS sg13g2_decap_8
XDEC1716 VDD VSS sg13g2_decap_8
XDEC1717 VDD VSS sg13g2_decap_8
XDEC1718 VDD VSS sg13g2_decap_8
XDEC1719 VDD VSS sg13g2_decap_8
XDEC1720 VDD VSS sg13g2_decap_8
XDEC1721 VDD VSS sg13g2_decap_8
XDEC1722 VDD VSS sg13g2_decap_8
XDEC1723 VDD VSS sg13g2_decap_8
XDEC1724 VDD VSS sg13g2_decap_8
XDEC1725 VDD VSS sg13g2_decap_8
XDEC1726 VDD VSS sg13g2_decap_8
XDEC1727 VDD VSS sg13g2_decap_8
XDEC1728 VDD VSS sg13g2_decap_8
XDEC1729 VDD VSS sg13g2_decap_8
XDEC1730 VDD VSS sg13g2_decap_8
XDEC1731 VDD VSS sg13g2_decap_8
XDEC1732 VDD VSS sg13g2_decap_8
XDEC1733 VDD VSS sg13g2_decap_8
XDEC1734 VDD VSS sg13g2_decap_8
XDEC1735 VDD VSS sg13g2_decap_8
XDEC1736 VDD VSS sg13g2_decap_8
XDEC1737 VDD VSS sg13g2_decap_8
XDEC1738 VDD VSS sg13g2_decap_8
XDEC1739 VDD VSS sg13g2_decap_8
XDEC1740 VDD VSS sg13g2_decap_8
XDEC1741 VDD VSS sg13g2_decap_8
XDEC1742 VDD VSS sg13g2_decap_8
XDEC1743 VDD VSS sg13g2_decap_8
XDEC1744 VDD VSS sg13g2_decap_8
XDEC1745 VDD VSS sg13g2_decap_8
XDEC1746 VDD VSS sg13g2_decap_8
XDEC1747 VDD VSS sg13g2_decap_8
XDEC1748 VDD VSS sg13g2_decap_8
XDEC1749 VDD VSS sg13g2_decap_8
XDEC1750 VDD VSS sg13g2_decap_8
XDEC1751 VDD VSS sg13g2_decap_8
XDEC1752 VDD VSS sg13g2_decap_8
XDEC1753 VDD VSS sg13g2_decap_8
XDEC1754 VDD VSS sg13g2_decap_8
XDEC1755 VDD VSS sg13g2_decap_8
XDEC1756 VDD VSS sg13g2_decap_8
XDEC1757 VDD VSS sg13g2_decap_8
XDEC1758 VDD VSS sg13g2_decap_8
XDEC1759 VDD VSS sg13g2_decap_8
XDEC1760 VDD VSS sg13g2_decap_8
XDEC1761 VDD VSS sg13g2_decap_8
XDEC1762 VDD VSS sg13g2_decap_8
XDEC1763 VDD VSS sg13g2_decap_8
XDEC1764 VDD VSS sg13g2_decap_8
XDEC1765 VDD VSS sg13g2_decap_8
XDEC1766 VDD VSS sg13g2_decap_8
XDEC1767 VDD VSS sg13g2_decap_8
XDEC1768 VDD VSS sg13g2_decap_8
XDEC1769 VDD VSS sg13g2_decap_8
XDEC1770 VDD VSS sg13g2_decap_8
XDEC1771 VDD VSS sg13g2_decap_8
XDEC1772 VDD VSS sg13g2_decap_8
XDEC1773 VDD VSS sg13g2_decap_8
XDEC1774 VDD VSS sg13g2_decap_8
XDEC1775 VDD VSS sg13g2_decap_8
XDEC1776 VDD VSS sg13g2_decap_8
XDEC1777 VDD VSS sg13g2_decap_8
XDEC1778 VDD VSS sg13g2_decap_8
XDEC1779 VDD VSS sg13g2_decap_8
XDEC1780 VDD VSS sg13g2_decap_8
XDEC1781 VDD VSS sg13g2_decap_8
XDEC1782 VDD VSS sg13g2_decap_8
XDEC1783 VDD VSS sg13g2_decap_8
XDEC1784 VDD VSS sg13g2_decap_8
XDEC1785 VDD VSS sg13g2_decap_8
XDEC1786 VDD VSS sg13g2_decap_8
XDEC1787 VDD VSS sg13g2_decap_8
XDEC1788 VDD VSS sg13g2_decap_8
XDEC1789 VDD VSS sg13g2_decap_8
XDEC1790 VDD VSS sg13g2_decap_8
XDEC1791 VDD VSS sg13g2_decap_8
XDEC1792 VDD VSS sg13g2_decap_8
XDEC1793 VDD VSS sg13g2_decap_8
XDEC1794 VDD VSS sg13g2_decap_8
XDEC1795 VDD VSS sg13g2_decap_8
XDEC1796 VDD VSS sg13g2_decap_8
XDEC1797 VDD VSS sg13g2_decap_8
XDEC1798 VDD VSS sg13g2_decap_8
XDEC1799 VDD VSS sg13g2_decap_8
XDEC1800 VDD VSS sg13g2_decap_8
XDEC1801 VDD VSS sg13g2_decap_8
XDEC1802 VDD VSS sg13g2_decap_8
XDEC1803 VDD VSS sg13g2_decap_8
XDEC1804 VDD VSS sg13g2_decap_8
XDEC1805 VDD VSS sg13g2_decap_8
XDEC1806 VDD VSS sg13g2_decap_8
XDEC1807 VDD VSS sg13g2_decap_8
XDEC1808 VDD VSS sg13g2_decap_8
XDEC1809 VDD VSS sg13g2_decap_8
XDEC1810 VDD VSS sg13g2_decap_8
XDEC1811 VDD VSS sg13g2_decap_8
XDEC1812 VDD VSS sg13g2_decap_8
XDEC1813 VDD VSS sg13g2_decap_8
XDEC1814 VDD VSS sg13g2_decap_8
XDEC1815 VDD VSS sg13g2_decap_8
XDEC1816 VDD VSS sg13g2_decap_8
XDEC1817 VDD VSS sg13g2_decap_8
XDEC1818 VDD VSS sg13g2_decap_8
XDEC1819 VDD VSS sg13g2_decap_8
XDEC1820 VDD VSS sg13g2_decap_8
XDEC1821 VDD VSS sg13g2_decap_8
XDEC1822 VDD VSS sg13g2_decap_8
XDEC1823 VDD VSS sg13g2_decap_8
XDEC1824 VDD VSS sg13g2_decap_8
XDEC1825 VDD VSS sg13g2_decap_8
XDEC1826 VDD VSS sg13g2_decap_8
XDEC1827 VDD VSS sg13g2_decap_8
XDEC1828 VDD VSS sg13g2_decap_8
XDEC1829 VDD VSS sg13g2_decap_8
XDEC1830 VDD VSS sg13g2_decap_8
XDEC1831 VDD VSS sg13g2_decap_8
XDEC1832 VDD VSS sg13g2_decap_8
XDEC1833 VDD VSS sg13g2_decap_8
XDEC1834 VDD VSS sg13g2_decap_8
XDEC1835 VDD VSS sg13g2_decap_8
XDEC1836 VDD VSS sg13g2_decap_8
XDEC1837 VDD VSS sg13g2_decap_8
XDEC1838 VDD VSS sg13g2_decap_8
XDEC1839 VDD VSS sg13g2_decap_8
XDEC1840 VDD VSS sg13g2_decap_8
XDEC1841 VDD VSS sg13g2_decap_8
XDEC1842 VDD VSS sg13g2_decap_8
XDEC1843 VDD VSS sg13g2_decap_8
XDEC1844 VDD VSS sg13g2_decap_8
XDEC1845 VDD VSS sg13g2_decap_8
XDEC1846 VDD VSS sg13g2_decap_8
XDEC1847 VDD VSS sg13g2_decap_8
XDEC1848 VDD VSS sg13g2_decap_8
XDEC1849 VDD VSS sg13g2_decap_8
XDEC1850 VDD VSS sg13g2_decap_8
XDEC1851 VDD VSS sg13g2_decap_8
XDEC1852 VDD VSS sg13g2_decap_8
XDEC1853 VDD VSS sg13g2_decap_8
XDEC1854 VDD VSS sg13g2_decap_8
XDEC1855 VDD VSS sg13g2_decap_8
XDEC1856 VDD VSS sg13g2_decap_8
XDEC1857 VDD VSS sg13g2_decap_8
XDEC1858 VDD VSS sg13g2_decap_8
XDEC1859 VDD VSS sg13g2_decap_8
XDEC1860 VDD VSS sg13g2_decap_8
XDEC1861 VDD VSS sg13g2_decap_8
XDEC1862 VDD VSS sg13g2_decap_8
XDEC1863 VDD VSS sg13g2_decap_8
XDEC1864 VDD VSS sg13g2_decap_8
XDEC1865 VDD VSS sg13g2_decap_8
XDEC1866 VDD VSS sg13g2_decap_8
XDEC1867 VDD VSS sg13g2_decap_8
XDEC1868 VDD VSS sg13g2_decap_8
XDEC1869 VDD VSS sg13g2_decap_8
XDEC1870 VDD VSS sg13g2_decap_8
XDEC1871 VDD VSS sg13g2_decap_8
XDEC1872 VDD VSS sg13g2_decap_8
XDEC1873 VDD VSS sg13g2_decap_8
XDEC1874 VDD VSS sg13g2_decap_8
XDEC1875 VDD VSS sg13g2_decap_8
XDEC1876 VDD VSS sg13g2_decap_8
XDEC1877 VDD VSS sg13g2_decap_8
XDEC1878 VDD VSS sg13g2_decap_8
XDEC1879 VDD VSS sg13g2_decap_8
XDEC1880 VDD VSS sg13g2_decap_8
XDEC1881 VDD VSS sg13g2_decap_8
XDEC1882 VDD VSS sg13g2_decap_8
XDEC1883 VDD VSS sg13g2_decap_8
XDEC1884 VDD VSS sg13g2_decap_8
XDEC1885 VDD VSS sg13g2_decap_8
XDEC1886 VDD VSS sg13g2_decap_8
XDEC1887 VDD VSS sg13g2_decap_8
XDEC1888 VDD VSS sg13g2_decap_8
XDEC1889 VDD VSS sg13g2_decap_8
XDEC1890 VDD VSS sg13g2_decap_8
XDEC1891 VDD VSS sg13g2_decap_8
XDEC1892 VDD VSS sg13g2_decap_8
XDEC1893 VDD VSS sg13g2_decap_8
XDEC1894 VDD VSS sg13g2_decap_8
XDEC1895 VDD VSS sg13g2_decap_8
XDEC1896 VDD VSS sg13g2_decap_8
XDEC1897 VDD VSS sg13g2_decap_8
XDEC1898 VDD VSS sg13g2_decap_8
XDEC1899 VDD VSS sg13g2_decap_8
XDEC1900 VDD VSS sg13g2_decap_8
XDEC1901 VDD VSS sg13g2_decap_8
XDEC1902 VDD VSS sg13g2_decap_8
XDEC1903 VDD VSS sg13g2_decap_8
XDEC1904 VDD VSS sg13g2_decap_8
XDEC1905 VDD VSS sg13g2_decap_8
XDEC1906 VDD VSS sg13g2_decap_8
XDEC1907 VDD VSS sg13g2_decap_8
XDEC1908 VDD VSS sg13g2_decap_8
XDEC1909 VDD VSS sg13g2_decap_8
XDEC1910 VDD VSS sg13g2_decap_8
XDEC1911 VDD VSS sg13g2_decap_8
XDEC1912 VDD VSS sg13g2_decap_8
XDEC1913 VDD VSS sg13g2_decap_8
XDEC1914 VDD VSS sg13g2_decap_8
XDEC1915 VDD VSS sg13g2_decap_8
XDEC1916 VDD VSS sg13g2_decap_8
XDEC1917 VDD VSS sg13g2_decap_8
XDEC1918 VDD VSS sg13g2_decap_8
XDEC1919 VDD VSS sg13g2_decap_8
XDEC1920 VDD VSS sg13g2_decap_8
XDEC1921 VDD VSS sg13g2_decap_8
XDEC1922 VDD VSS sg13g2_decap_8
XDEC1923 VDD VSS sg13g2_decap_8
XDEC1924 VDD VSS sg13g2_decap_8
XDEC1925 VDD VSS sg13g2_decap_8
XDEC1926 VDD VSS sg13g2_decap_8
XDEC1927 VDD VSS sg13g2_decap_8
XDEC1928 VDD VSS sg13g2_decap_8
XDEC1929 VDD VSS sg13g2_decap_8
XDEC1930 VDD VSS sg13g2_decap_8
XDEC1931 VDD VSS sg13g2_decap_8
XDEC1932 VDD VSS sg13g2_decap_8
XDEC1933 VDD VSS sg13g2_decap_8
XDEC1934 VDD VSS sg13g2_decap_8
XDEC1935 VDD VSS sg13g2_decap_8
XDEC1936 VDD VSS sg13g2_decap_8
XDEC1937 VDD VSS sg13g2_decap_8
XDEC1938 VDD VSS sg13g2_decap_8
XDEC1939 VDD VSS sg13g2_decap_8
XDEC1940 VDD VSS sg13g2_decap_8
XDEC1941 VDD VSS sg13g2_decap_8
XDEC1942 VDD VSS sg13g2_decap_8
XDEC1943 VDD VSS sg13g2_decap_8
XDEC1944 VDD VSS sg13g2_decap_8
XDEC1945 VDD VSS sg13g2_decap_8
XDEC1946 VDD VSS sg13g2_decap_8
XDEC1947 VDD VSS sg13g2_decap_8
XDEC1948 VDD VSS sg13g2_decap_8
XDEC1949 VDD VSS sg13g2_decap_8
XDEC1950 VDD VSS sg13g2_decap_8
XDEC1951 VDD VSS sg13g2_decap_8
XDEC1952 VDD VSS sg13g2_decap_8
XDEC1953 VDD VSS sg13g2_decap_8
XDEC1954 VDD VSS sg13g2_decap_8
XDEC1955 VDD VSS sg13g2_decap_8
XDEC1956 VDD VSS sg13g2_decap_8
XDEC1957 VDD VSS sg13g2_decap_8
XDEC1958 VDD VSS sg13g2_decap_8
XDEC1959 VDD VSS sg13g2_decap_8
XDEC1960 VDD VSS sg13g2_decap_8
XDEC1961 VDD VSS sg13g2_decap_8
XDEC1962 VDD VSS sg13g2_decap_8
XDEC1963 VDD VSS sg13g2_decap_8
XDEC1964 VDD VSS sg13g2_decap_8
XDEC1965 VDD VSS sg13g2_decap_8
XDEC1966 VDD VSS sg13g2_decap_8
XDEC1967 VDD VSS sg13g2_decap_8
XDEC1968 VDD VSS sg13g2_decap_8
XDEC1969 VDD VSS sg13g2_decap_8
XDEC1970 VDD VSS sg13g2_decap_8
XDEC1971 VDD VSS sg13g2_decap_8
XDEC1972 VDD VSS sg13g2_decap_8
XDEC1973 VDD VSS sg13g2_decap_8
XDEC1974 VDD VSS sg13g2_decap_8
XDEC1975 VDD VSS sg13g2_decap_8
XDEC1976 VDD VSS sg13g2_decap_8
XDEC1977 VDD VSS sg13g2_decap_8
XDEC1978 VDD VSS sg13g2_decap_8
XDEC1979 VDD VSS sg13g2_decap_8
XDEC1980 VDD VSS sg13g2_decap_8
XDEC1981 VDD VSS sg13g2_decap_8
XDEC1982 VDD VSS sg13g2_decap_8
XDEC1983 VDD VSS sg13g2_decap_8
XDEC1984 VDD VSS sg13g2_decap_8
XDEC1985 VDD VSS sg13g2_decap_8
XDEC1986 VDD VSS sg13g2_decap_8
XDEC1987 VDD VSS sg13g2_decap_8
XDEC1988 VDD VSS sg13g2_decap_8
XDEC1989 VDD VSS sg13g2_decap_8
XDEC1990 VDD VSS sg13g2_decap_8
XDEC1991 VDD VSS sg13g2_decap_8
XDEC1992 VDD VSS sg13g2_decap_8
XDEC1993 VDD VSS sg13g2_decap_8
XDEC1994 VDD VSS sg13g2_decap_8
XDEC1995 VDD VSS sg13g2_decap_8
XDEC1996 VDD VSS sg13g2_decap_8
XDEC1997 VDD VSS sg13g2_decap_8
XDEC1998 VDD VSS sg13g2_decap_8
XDEC1999 VDD VSS sg13g2_decap_8
XDEC2000 VDD VSS sg13g2_decap_8
XDEC2001 VDD VSS sg13g2_decap_8
XDEC2002 VDD VSS sg13g2_decap_8
XDEC2003 VDD VSS sg13g2_decap_8
XDEC2004 VDD VSS sg13g2_decap_8
XDEC2005 VDD VSS sg13g2_decap_8
XDEC2006 VDD VSS sg13g2_decap_8
XDEC2007 VDD VSS sg13g2_decap_8
XDEC2008 VDD VSS sg13g2_decap_8
XDEC2009 VDD VSS sg13g2_decap_8
XDEC2010 VDD VSS sg13g2_decap_8
XDEC2011 VDD VSS sg13g2_decap_8
XDEC2012 VDD VSS sg13g2_decap_8
XDEC2013 VDD VSS sg13g2_decap_8
XDEC2014 VDD VSS sg13g2_decap_8
XDEC2015 VDD VSS sg13g2_decap_8
XDEC2016 VDD VSS sg13g2_decap_8
XDEC2017 VDD VSS sg13g2_decap_8
XDEC2018 VDD VSS sg13g2_decap_8
XDEC2019 VDD VSS sg13g2_decap_8
XDEC2020 VDD VSS sg13g2_decap_8
XDEC2021 VDD VSS sg13g2_decap_8
XDEC2022 VDD VSS sg13g2_decap_8
XDEC2023 VDD VSS sg13g2_decap_8
XDEC2024 VDD VSS sg13g2_decap_8
XDEC2025 VDD VSS sg13g2_decap_8
XDEC2026 VDD VSS sg13g2_decap_8
XDEC2027 VDD VSS sg13g2_decap_8
XDEC2028 VDD VSS sg13g2_decap_8
XDEC2029 VDD VSS sg13g2_decap_8
XDEC2030 VDD VSS sg13g2_decap_8
XDEC2031 VDD VSS sg13g2_decap_8
XDEC2032 VDD VSS sg13g2_decap_8
XDEC2033 VDD VSS sg13g2_decap_8
XDEC2034 VDD VSS sg13g2_decap_8
XDEC2035 VDD VSS sg13g2_decap_8
XDEC2036 VDD VSS sg13g2_decap_8
XDEC2037 VDD VSS sg13g2_decap_8
XDEC2038 VDD VSS sg13g2_decap_8
XDEC2039 VDD VSS sg13g2_decap_8
XDEC2040 VDD VSS sg13g2_decap_8
XDEC2041 VDD VSS sg13g2_decap_8
XDEC2042 VDD VSS sg13g2_decap_8
XDEC2043 VDD VSS sg13g2_decap_8
XDEC2044 VDD VSS sg13g2_decap_8
XDEC2045 VDD VSS sg13g2_decap_8
XDEC2046 VDD VSS sg13g2_decap_8
XDEC2047 VDD VSS sg13g2_decap_8
XDEC2048 VDD VSS sg13g2_decap_8
XDEC2049 VDD VSS sg13g2_decap_8
XDEC2050 VDD VSS sg13g2_decap_8
XDEC2051 VDD VSS sg13g2_decap_8
XDEC2052 VDD VSS sg13g2_decap_8
XDEC2053 VDD VSS sg13g2_decap_8
XDEC2054 VDD VSS sg13g2_decap_8
XDEC2055 VDD VSS sg13g2_decap_8
XDEC2056 VDD VSS sg13g2_decap_8
XDEC2057 VDD VSS sg13g2_decap_8
XDEC2058 VDD VSS sg13g2_decap_8
XDEC2059 VDD VSS sg13g2_decap_8
XDEC2060 VDD VSS sg13g2_decap_8
XDEC2061 VDD VSS sg13g2_decap_8
XDEC2062 VDD VSS sg13g2_decap_8
XDEC2063 VDD VSS sg13g2_decap_8
XDEC2064 VDD VSS sg13g2_decap_8
XDEC2065 VDD VSS sg13g2_decap_8
XDEC2066 VDD VSS sg13g2_decap_8
XDEC2067 VDD VSS sg13g2_decap_8
XDEC2068 VDD VSS sg13g2_decap_8
XDEC2069 VDD VSS sg13g2_decap_8
XDEC2070 VDD VSS sg13g2_decap_8
XDEC2071 VDD VSS sg13g2_decap_8
XDEC2072 VDD VSS sg13g2_decap_8
XDEC2073 VDD VSS sg13g2_decap_8
XDEC2074 VDD VSS sg13g2_decap_8
XDEC2075 VDD VSS sg13g2_decap_8
XDEC2076 VDD VSS sg13g2_decap_8
XDEC2077 VDD VSS sg13g2_decap_8
XDEC2078 VDD VSS sg13g2_decap_8
XDEC2079 VDD VSS sg13g2_decap_8
XDEC2080 VDD VSS sg13g2_decap_8
XDEC2081 VDD VSS sg13g2_decap_8
XDEC2082 VDD VSS sg13g2_decap_8
XDEC2083 VDD VSS sg13g2_decap_8
XDEC2084 VDD VSS sg13g2_decap_8
XDEC2085 VDD VSS sg13g2_decap_8
XDEC2086 VDD VSS sg13g2_decap_8
XDEC2087 VDD VSS sg13g2_decap_8
XDEC2088 VDD VSS sg13g2_decap_8
XDEC2089 VDD VSS sg13g2_decap_8
XDEC2090 VDD VSS sg13g2_decap_8
XDEC2091 VDD VSS sg13g2_decap_8
XDEC2092 VDD VSS sg13g2_decap_8
XDEC2093 VDD VSS sg13g2_decap_8
XDEC2094 VDD VSS sg13g2_decap_8
XDEC2095 VDD VSS sg13g2_decap_8
XDEC2096 VDD VSS sg13g2_decap_8
XDEC2097 VDD VSS sg13g2_decap_8
XDEC2098 VDD VSS sg13g2_decap_8
XDEC2099 VDD VSS sg13g2_decap_8
XDEC2100 VDD VSS sg13g2_decap_8
XDEC2101 VDD VSS sg13g2_decap_8
XDEC2102 VDD VSS sg13g2_decap_8
XDEC2103 VDD VSS sg13g2_decap_8
XDEC2104 VDD VSS sg13g2_decap_8
XDEC2105 VDD VSS sg13g2_decap_8
XDEC2106 VDD VSS sg13g2_decap_8
XDEC2107 VDD VSS sg13g2_decap_8
XDEC2108 VDD VSS sg13g2_decap_8
XDEC2109 VDD VSS sg13g2_decap_8
XDEC2110 VDD VSS sg13g2_decap_8
XDEC2111 VDD VSS sg13g2_decap_8
XDEC2112 VDD VSS sg13g2_decap_8
XDEC2113 VDD VSS sg13g2_decap_8
XDEC2114 VDD VSS sg13g2_decap_8
XDEC2115 VDD VSS sg13g2_decap_8
XDEC2116 VDD VSS sg13g2_decap_8
XDEC2117 VDD VSS sg13g2_decap_8
XDEC2118 VDD VSS sg13g2_decap_8
XDEC2119 VDD VSS sg13g2_decap_8
XDEC2120 VDD VSS sg13g2_decap_8
XDEC2121 VDD VSS sg13g2_decap_8
XDEC2122 VDD VSS sg13g2_decap_8
XDEC2123 VDD VSS sg13g2_decap_8
XDEC2124 VDD VSS sg13g2_decap_8
XDEC2125 VDD VSS sg13g2_decap_8
XDEC2126 VDD VSS sg13g2_decap_8
XDEC2127 VDD VSS sg13g2_decap_8
XDEC2128 VDD VSS sg13g2_decap_8
XDEC2129 VDD VSS sg13g2_decap_8
XDEC2130 VDD VSS sg13g2_decap_8
XDEC2131 VDD VSS sg13g2_decap_8
XDEC2132 VDD VSS sg13g2_decap_8
XDEC2133 VDD VSS sg13g2_decap_8
XDEC2134 VDD VSS sg13g2_decap_8
XDEC2135 VDD VSS sg13g2_decap_8
XDEC2136 VDD VSS sg13g2_decap_8
XDEC2137 VDD VSS sg13g2_decap_8
XDEC2138 VDD VSS sg13g2_decap_8
XDEC2139 VDD VSS sg13g2_decap_8
XDEC2140 VDD VSS sg13g2_decap_8
XDEC2141 VDD VSS sg13g2_decap_8
XDEC2142 VDD VSS sg13g2_decap_8
XDEC2143 VDD VSS sg13g2_decap_8
XDEC2144 VDD VSS sg13g2_decap_8
XDEC2145 VDD VSS sg13g2_decap_8
XDEC2146 VDD VSS sg13g2_decap_8
XDEC2147 VDD VSS sg13g2_decap_8
XDEC2148 VDD VSS sg13g2_decap_8
XDEC2149 VDD VSS sg13g2_decap_8
XDEC2150 VDD VSS sg13g2_decap_8
XDEC2151 VDD VSS sg13g2_decap_8
XDEC2152 VDD VSS sg13g2_decap_8
XDEC2153 VDD VSS sg13g2_decap_8
XDEC2154 VDD VSS sg13g2_decap_8
XDEC2155 VDD VSS sg13g2_decap_8
XDEC2156 VDD VSS sg13g2_decap_8
XDEC2157 VDD VSS sg13g2_decap_8
XDEC2158 VDD VSS sg13g2_decap_8
XDEC2159 VDD VSS sg13g2_decap_8
XDEC2160 VDD VSS sg13g2_decap_8
XDEC2161 VDD VSS sg13g2_decap_8
XDEC2162 VDD VSS sg13g2_decap_8
XDEC2163 VDD VSS sg13g2_decap_8
XDEC2164 VDD VSS sg13g2_decap_8
XDEC2165 VDD VSS sg13g2_decap_8
XDEC2166 VDD VSS sg13g2_decap_8
XDEC2167 VDD VSS sg13g2_decap_8
XDEC2168 VDD VSS sg13g2_decap_8
XDEC2169 VDD VSS sg13g2_decap_8
XDEC2170 VDD VSS sg13g2_decap_8
XDEC2171 VDD VSS sg13g2_decap_8
XDEC2172 VDD VSS sg13g2_decap_8
XDEC2173 VDD VSS sg13g2_decap_8
XDEC2174 VDD VSS sg13g2_decap_8
XDEC2175 VDD VSS sg13g2_decap_8
XDEC2176 VDD VSS sg13g2_decap_8
XDEC2177 VDD VSS sg13g2_decap_8
XDEC2178 VDD VSS sg13g2_decap_8
XDEC2179 VDD VSS sg13g2_decap_8
XDEC2180 VDD VSS sg13g2_decap_8
XDEC2181 VDD VSS sg13g2_decap_8
XDEC2182 VDD VSS sg13g2_decap_8
XDEC2183 VDD VSS sg13g2_decap_8
XDEC2184 VDD VSS sg13g2_decap_8
XDEC2185 VDD VSS sg13g2_decap_8
XDEC2186 VDD VSS sg13g2_decap_8
XDEC2187 VDD VSS sg13g2_decap_8
XDEC2188 VDD VSS sg13g2_decap_8
XDEC2189 VDD VSS sg13g2_decap_8
XDEC2190 VDD VSS sg13g2_decap_8
XDEC2191 VDD VSS sg13g2_decap_8
XDEC2192 VDD VSS sg13g2_decap_8
XDEC2193 VDD VSS sg13g2_decap_8
XDEC2194 VDD VSS sg13g2_decap_8
XDEC2195 VDD VSS sg13g2_decap_8
XDEC2196 VDD VSS sg13g2_decap_8
XDEC2197 VDD VSS sg13g2_decap_8
XDEC2198 VDD VSS sg13g2_decap_8
XDEC2199 VDD VSS sg13g2_decap_8
XDEC2200 VDD VSS sg13g2_decap_8
XDEC2201 VDD VSS sg13g2_decap_8
XDEC2202 VDD VSS sg13g2_decap_8
XDEC2203 VDD VSS sg13g2_decap_8
XDEC2204 VDD VSS sg13g2_decap_8
XDEC2205 VDD VSS sg13g2_decap_8
XDEC2206 VDD VSS sg13g2_decap_8
XDEC2207 VDD VSS sg13g2_decap_8
XDEC2208 VDD VSS sg13g2_decap_8
XDEC2209 VDD VSS sg13g2_decap_8
XDEC2210 VDD VSS sg13g2_decap_8
XDEC2211 VDD VSS sg13g2_decap_8
XDEC2212 VDD VSS sg13g2_decap_8
XDEC2213 VDD VSS sg13g2_decap_8
XDEC2214 VDD VSS sg13g2_decap_8
XDEC2215 VDD VSS sg13g2_decap_8
XDEC2216 VDD VSS sg13g2_decap_8
XDEC2217 VDD VSS sg13g2_decap_8
XDEC2218 VDD VSS sg13g2_decap_8
XDEC2219 VDD VSS sg13g2_decap_8
XDEC2220 VDD VSS sg13g2_decap_8
XDEC2221 VDD VSS sg13g2_decap_8
XDEC2222 VDD VSS sg13g2_decap_8
XDEC2223 VDD VSS sg13g2_decap_8
XDEC2224 VDD VSS sg13g2_decap_8
XDEC2225 VDD VSS sg13g2_decap_8
XDEC2226 VDD VSS sg13g2_decap_8
XDEC2227 VDD VSS sg13g2_decap_8
XDEC2228 VDD VSS sg13g2_decap_8
XDEC2229 VDD VSS sg13g2_decap_8
XDEC2230 VDD VSS sg13g2_decap_8
XDEC2231 VDD VSS sg13g2_decap_8
XDEC2232 VDD VSS sg13g2_decap_8
XDEC2233 VDD VSS sg13g2_decap_8
XDEC2234 VDD VSS sg13g2_decap_8
XDEC2235 VDD VSS sg13g2_decap_8
XDEC2236 VDD VSS sg13g2_decap_8
XDEC2237 VDD VSS sg13g2_decap_8
XDEC2238 VDD VSS sg13g2_decap_8
XDEC2239 VDD VSS sg13g2_decap_8
XDEC2240 VDD VSS sg13g2_decap_8
XDEC2241 VDD VSS sg13g2_decap_8
XDEC2242 VDD VSS sg13g2_decap_8
XDEC2243 VDD VSS sg13g2_decap_8
XDEC2244 VDD VSS sg13g2_decap_8
XDEC2245 VDD VSS sg13g2_decap_8
XDEC2246 VDD VSS sg13g2_decap_8
XDEC2247 VDD VSS sg13g2_decap_8
XDEC2248 VDD VSS sg13g2_decap_8
XDEC2249 VDD VSS sg13g2_decap_8
XDEC2250 VDD VSS sg13g2_decap_8
XDEC2251 VDD VSS sg13g2_decap_8
XDEC2252 VDD VSS sg13g2_decap_8
XDEC2253 VDD VSS sg13g2_decap_8
XDEC2254 VDD VSS sg13g2_decap_8
XDEC2255 VDD VSS sg13g2_decap_8
XDEC2256 VDD VSS sg13g2_decap_8
XDEC2257 VDD VSS sg13g2_decap_8
XDEC2258 VDD VSS sg13g2_decap_8
XDEC2259 VDD VSS sg13g2_decap_8
XDEC2260 VDD VSS sg13g2_decap_8
XDEC2261 VDD VSS sg13g2_decap_8
XDEC2262 VDD VSS sg13g2_decap_8
XDEC2263 VDD VSS sg13g2_decap_8
XDEC2264 VDD VSS sg13g2_decap_8
XDEC2265 VDD VSS sg13g2_decap_8
XDEC2266 VDD VSS sg13g2_decap_8
XDEC2267 VDD VSS sg13g2_decap_8
XDEC2268 VDD VSS sg13g2_decap_8
XDEC2269 VDD VSS sg13g2_decap_8
XDEC2270 VDD VSS sg13g2_decap_8
XDEC2271 VDD VSS sg13g2_decap_8
XDEC2272 VDD VSS sg13g2_decap_8
XDEC2273 VDD VSS sg13g2_decap_8
XDEC2274 VDD VSS sg13g2_decap_8
XDEC2275 VDD VSS sg13g2_decap_8
XDEC2276 VDD VSS sg13g2_decap_8
XDEC2277 VDD VSS sg13g2_decap_8
XDEC2278 VDD VSS sg13g2_decap_8
XDEC2279 VDD VSS sg13g2_decap_8
XDEC2280 VDD VSS sg13g2_decap_8
XDEC2281 VDD VSS sg13g2_decap_8
XDEC2282 VDD VSS sg13g2_decap_8
XDEC2283 VDD VSS sg13g2_decap_8
XDEC2284 VDD VSS sg13g2_decap_8
XDEC2285 VDD VSS sg13g2_decap_8
XDEC2286 VDD VSS sg13g2_decap_8
XDEC2287 VDD VSS sg13g2_decap_8
XDEC2288 VDD VSS sg13g2_decap_8
XDEC2289 VDD VSS sg13g2_decap_8
XDEC2290 VDD VSS sg13g2_decap_8
XDEC2291 VDD VSS sg13g2_decap_8
XDEC2292 VDD VSS sg13g2_decap_8
XDEC2293 VDD VSS sg13g2_decap_8
XDEC2294 VDD VSS sg13g2_decap_8
XDEC2295 VDD VSS sg13g2_decap_8
XDEC2296 VDD VSS sg13g2_decap_8
XDEC2297 VDD VSS sg13g2_decap_8
XDEC2298 VDD VSS sg13g2_decap_8
XDEC2299 VDD VSS sg13g2_decap_8
XDEC2300 VDD VSS sg13g2_decap_8
XDEC2301 VDD VSS sg13g2_decap_8
XDEC2302 VDD VSS sg13g2_decap_8
XDEC2303 VDD VSS sg13g2_decap_8
XDEC2304 VDD VSS sg13g2_decap_8
XDEC2305 VDD VSS sg13g2_decap_8
XDEC2306 VDD VSS sg13g2_decap_8
XDEC2307 VDD VSS sg13g2_decap_8
XDEC2308 VDD VSS sg13g2_decap_8
XDEC2309 VDD VSS sg13g2_decap_8
XDEC2310 VDD VSS sg13g2_decap_8
XDEC2311 VDD VSS sg13g2_decap_8
XDEC2312 VDD VSS sg13g2_decap_8
XDEC2313 VDD VSS sg13g2_decap_8
XDEC2314 VDD VSS sg13g2_decap_8
XDEC2315 VDD VSS sg13g2_decap_8
XDEC2316 VDD VSS sg13g2_decap_8
XDEC2317 VDD VSS sg13g2_decap_8
XDEC2318 VDD VSS sg13g2_decap_8
XDEC2319 VDD VSS sg13g2_decap_8
XDEC2320 VDD VSS sg13g2_decap_8
XDEC2321 VDD VSS sg13g2_decap_8
XDEC2322 VDD VSS sg13g2_decap_8
XDEC2323 VDD VSS sg13g2_decap_8
XDEC2324 VDD VSS sg13g2_decap_8
XDEC2325 VDD VSS sg13g2_decap_8
XDEC2326 VDD VSS sg13g2_decap_8
XDEC2327 VDD VSS sg13g2_decap_8
XDEC2328 VDD VSS sg13g2_decap_8
XDEC2329 VDD VSS sg13g2_decap_8
XDEC2330 VDD VSS sg13g2_decap_8
XDEC2331 VDD VSS sg13g2_decap_8
XDEC2332 VDD VSS sg13g2_decap_8
XDEC2333 VDD VSS sg13g2_decap_8
XDEC2334 VDD VSS sg13g2_decap_8
XDEC2335 VDD VSS sg13g2_decap_8
XDEC2336 VDD VSS sg13g2_decap_8
XDEC2337 VDD VSS sg13g2_decap_8
XDEC2338 VDD VSS sg13g2_decap_8
XDEC2339 VDD VSS sg13g2_decap_8
XDEC2340 VDD VSS sg13g2_decap_8
XDEC2341 VDD VSS sg13g2_decap_8
XDEC2342 VDD VSS sg13g2_decap_8
XDEC2343 VDD VSS sg13g2_decap_8
XDEC2344 VDD VSS sg13g2_decap_8
XDEC2345 VDD VSS sg13g2_decap_8
XDEC2346 VDD VSS sg13g2_decap_8
XDEC2347 VDD VSS sg13g2_decap_8
XDEC2348 VDD VSS sg13g2_decap_8
XDEC2349 VDD VSS sg13g2_decap_8
XDEC2350 VDD VSS sg13g2_decap_8
XDEC2351 VDD VSS sg13g2_decap_8
XDEC2352 VDD VSS sg13g2_decap_8
XDEC2353 VDD VSS sg13g2_decap_8
XDEC2354 VDD VSS sg13g2_decap_8
XDEC2355 VDD VSS sg13g2_decap_8
XDEC2356 VDD VSS sg13g2_decap_8
XDEC2357 VDD VSS sg13g2_decap_8
XDEC2358 VDD VSS sg13g2_decap_8
XDEC2359 VDD VSS sg13g2_decap_8
XDEC2360 VDD VSS sg13g2_decap_8
XDEC2361 VDD VSS sg13g2_decap_8
XDEC2362 VDD VSS sg13g2_decap_8
XDEC2363 VDD VSS sg13g2_decap_8
XDEC2364 VDD VSS sg13g2_decap_8
XDEC2365 VDD VSS sg13g2_decap_8
XDEC2366 VDD VSS sg13g2_decap_8
XDEC2367 VDD VSS sg13g2_decap_8
XDEC2368 VDD VSS sg13g2_decap_8
XDEC2369 VDD VSS sg13g2_decap_8
XDEC2370 VDD VSS sg13g2_decap_8
XDEC2371 VDD VSS sg13g2_decap_8
XDEC2372 VDD VSS sg13g2_decap_8
XDEC2373 VDD VSS sg13g2_decap_8
XDEC2374 VDD VSS sg13g2_decap_8
XDEC2375 VDD VSS sg13g2_decap_8
XDEC2376 VDD VSS sg13g2_decap_8
XDEC2377 VDD VSS sg13g2_decap_8
XDEC2378 VDD VSS sg13g2_decap_8
XDEC2379 VDD VSS sg13g2_decap_8
XDEC2380 VDD VSS sg13g2_decap_8
XDEC2381 VDD VSS sg13g2_decap_8
XDEC2382 VDD VSS sg13g2_decap_8
XDEC2383 VDD VSS sg13g2_decap_8
XDEC2384 VDD VSS sg13g2_decap_8
XDEC2385 VDD VSS sg13g2_decap_8
XDEC2386 VDD VSS sg13g2_decap_8
XDEC2387 VDD VSS sg13g2_decap_8
XDEC2388 VDD VSS sg13g2_decap_8
XDEC2389 VDD VSS sg13g2_decap_8
XDEC2390 VDD VSS sg13g2_decap_8
XDEC2391 VDD VSS sg13g2_decap_8
XDEC2392 VDD VSS sg13g2_decap_8
XDEC2393 VDD VSS sg13g2_decap_8
XDEC2394 VDD VSS sg13g2_decap_8
XDEC2395 VDD VSS sg13g2_decap_8
XDEC2396 VDD VSS sg13g2_decap_8
XDEC2397 VDD VSS sg13g2_decap_8
XDEC2398 VDD VSS sg13g2_decap_8
XDEC2399 VDD VSS sg13g2_decap_8
XDEC2400 VDD VSS sg13g2_decap_8
XDEC2401 VDD VSS sg13g2_decap_8
XDEC2402 VDD VSS sg13g2_decap_8
XDEC2403 VDD VSS sg13g2_decap_8
XDEC2404 VDD VSS sg13g2_decap_8
XDEC2405 VDD VSS sg13g2_decap_8
XDEC2406 VDD VSS sg13g2_decap_8
XDEC2407 VDD VSS sg13g2_decap_8
XDEC2408 VDD VSS sg13g2_decap_8
XDEC2409 VDD VSS sg13g2_decap_8
XDEC2410 VDD VSS sg13g2_decap_8
XDEC2411 VDD VSS sg13g2_decap_8
XDEC2412 VDD VSS sg13g2_decap_8
XDEC2413 VDD VSS sg13g2_decap_8
XDEC2414 VDD VSS sg13g2_decap_8
XDEC2415 VDD VSS sg13g2_decap_8
XDEC2416 VDD VSS sg13g2_decap_8
XDEC2417 VDD VSS sg13g2_decap_8
XDEC2418 VDD VSS sg13g2_decap_8
XDEC2419 VDD VSS sg13g2_decap_8
XDEC2420 VDD VSS sg13g2_decap_8
XDEC2421 VDD VSS sg13g2_decap_8
XDEC2422 VDD VSS sg13g2_decap_8
XDEC2423 VDD VSS sg13g2_decap_8
XDEC2424 VDD VSS sg13g2_decap_8
XDEC2425 VDD VSS sg13g2_decap_8
XDEC2426 VDD VSS sg13g2_decap_8
XDEC2427 VDD VSS sg13g2_decap_8
XDEC2428 VDD VSS sg13g2_decap_8
XDEC2429 VDD VSS sg13g2_decap_8
XDEC2430 VDD VSS sg13g2_decap_8
XDEC2431 VDD VSS sg13g2_decap_8
XDEC2432 VDD VSS sg13g2_decap_8
XDEC2433 VDD VSS sg13g2_decap_8
XDEC2434 VDD VSS sg13g2_decap_8
XDEC2435 VDD VSS sg13g2_decap_8
XDEC2436 VDD VSS sg13g2_decap_8
XDEC2437 VDD VSS sg13g2_decap_8
XDEC2438 VDD VSS sg13g2_decap_8
XDEC2439 VDD VSS sg13g2_decap_8
XDEC2440 VDD VSS sg13g2_decap_8
XDEC2441 VDD VSS sg13g2_decap_8
XDEC2442 VDD VSS sg13g2_decap_8
XDEC2443 VDD VSS sg13g2_decap_8

XDEC2444 VDD VSS sg13g2_decap_4
XDEC2445 VDD VSS sg13g2_decap_4
XDEC2446 VDD VSS sg13g2_decap_4
XDEC2447 VDD VSS sg13g2_decap_4
XDEC2448 VDD VSS sg13g2_decap_4
XDEC2449 VDD VSS sg13g2_decap_4
XDEC2450 VDD VSS sg13g2_decap_4
XDEC2451 VDD VSS sg13g2_decap_4
XDEC2452 VDD VSS sg13g2_decap_4
XDEC2453 VDD VSS sg13g2_decap_4
XDEC2454 VDD VSS sg13g2_decap_4
XDEC2455 VDD VSS sg13g2_decap_4
XDEC2456 VDD VSS sg13g2_decap_4
XDEC2457 VDD VSS sg13g2_decap_4
XDEC2458 VDD VSS sg13g2_decap_4
XDEC2459 VDD VSS sg13g2_decap_4
XDEC2460 VDD VSS sg13g2_decap_4
XDEC2461 VDD VSS sg13g2_decap_4
XDEC2462 VDD VSS sg13g2_decap_4
XDEC2463 VDD VSS sg13g2_decap_4
XDEC2464 VDD VSS sg13g2_decap_4
XDEC2465 VDD VSS sg13g2_decap_4
XDEC2466 VDD VSS sg13g2_decap_4
XDEC2467 VDD VSS sg13g2_decap_4
XDEC2468 VDD VSS sg13g2_decap_4
XDEC2469 VDD VSS sg13g2_decap_4
XDEC2470 VDD VSS sg13g2_decap_4
XDEC2471 VDD VSS sg13g2_decap_4
XDEC2472 VDD VSS sg13g2_decap_4
XDEC2473 VDD VSS sg13g2_decap_4
XDEC2474 VDD VSS sg13g2_decap_4
XDEC2475 VDD VSS sg13g2_decap_4
XDEC2476 VDD VSS sg13g2_decap_4
XDEC2477 VDD VSS sg13g2_decap_4
XDEC2478 VDD VSS sg13g2_decap_4
XDEC2479 VDD VSS sg13g2_decap_4
XDEC2480 VDD VSS sg13g2_decap_4
XDEC2481 VDD VSS sg13g2_decap_4
XDEC2482 VDD VSS sg13g2_decap_4
XDEC2483 VDD VSS sg13g2_decap_4
XDEC2484 VDD VSS sg13g2_decap_4
XDEC2485 VDD VSS sg13g2_decap_4
XDEC2486 VDD VSS sg13g2_decap_4
XDEC2487 VDD VSS sg13g2_decap_4
XDEC2488 VDD VSS sg13g2_decap_4
XDEC2489 VDD VSS sg13g2_decap_4
XDEC2490 VDD VSS sg13g2_decap_4
XDEC2491 VDD VSS sg13g2_decap_4
XDEC2492 VDD VSS sg13g2_decap_4
XDEC2493 VDD VSS sg13g2_decap_4
XDEC2494 VDD VSS sg13g2_decap_4
XDEC2495 VDD VSS sg13g2_decap_4
XDEC2496 VDD VSS sg13g2_decap_4
XDEC2497 VDD VSS sg13g2_decap_4
XDEC2498 VDD VSS sg13g2_decap_4
XDEC2499 VDD VSS sg13g2_decap_4
XDEC2500 VDD VSS sg13g2_decap_4
XDEC2501 VDD VSS sg13g2_decap_4
XDEC2502 VDD VSS sg13g2_decap_4
XDEC2503 VDD VSS sg13g2_decap_4
XDEC2504 VDD VSS sg13g2_decap_4
XDEC2505 VDD VSS sg13g2_decap_4
XDEC2506 VDD VSS sg13g2_decap_4
XDEC2507 VDD VSS sg13g2_decap_4
XDEC2508 VDD VSS sg13g2_decap_4
XDEC2509 VDD VSS sg13g2_decap_4
XDEC2510 VDD VSS sg13g2_decap_4
XDEC2511 VDD VSS sg13g2_decap_4
XDEC2512 VDD VSS sg13g2_decap_4
XDEC2513 VDD VSS sg13g2_decap_4
XDEC2514 VDD VSS sg13g2_decap_4
XDEC2515 VDD VSS sg13g2_decap_4
XDEC2516 VDD VSS sg13g2_decap_4
XDEC2517 VDD VSS sg13g2_decap_4
XDEC2518 VDD VSS sg13g2_decap_4
XDEC2519 VDD VSS sg13g2_decap_4
XDEC2520 VDD VSS sg13g2_decap_4
XDEC2521 VDD VSS sg13g2_decap_4
XDEC2522 VDD VSS sg13g2_decap_4
XDEC2523 VDD VSS sg13g2_decap_4
XDEC2524 VDD VSS sg13g2_decap_4
XDEC2525 VDD VSS sg13g2_decap_4
XDEC2526 VDD VSS sg13g2_decap_4
XDEC2527 VDD VSS sg13g2_decap_4
XDEC2528 VDD VSS sg13g2_decap_4
XDEC2529 VDD VSS sg13g2_decap_4
XDEC2530 VDD VSS sg13g2_decap_4
XDEC2531 VDD VSS sg13g2_decap_4
XDEC2532 VDD VSS sg13g2_decap_4
XDEC2533 VDD VSS sg13g2_decap_4
XDEC2534 VDD VSS sg13g2_decap_4
XDEC2535 VDD VSS sg13g2_decap_4
XDEC2536 VDD VSS sg13g2_decap_4
XDEC2537 VDD VSS sg13g2_decap_4
XDEC2538 VDD VSS sg13g2_decap_4
XDEC2539 VDD VSS sg13g2_decap_4
XDEC2540 VDD VSS sg13g2_decap_4
XDEC2541 VDD VSS sg13g2_decap_4
XDEC2542 VDD VSS sg13g2_decap_4
XDEC2543 VDD VSS sg13g2_decap_4
XDEC2544 VDD VSS sg13g2_decap_4
XDEC2545 VDD VSS sg13g2_decap_4
XDEC2546 VDD VSS sg13g2_decap_4
XDEC2547 VDD VSS sg13g2_decap_4
XDEC2548 VDD VSS sg13g2_decap_4
XDEC2549 VDD VSS sg13g2_decap_4
XDEC2550 VDD VSS sg13g2_decap_4
XDEC2551 VDD VSS sg13g2_decap_4
XDEC2552 VDD VSS sg13g2_decap_4
XDEC2553 VDD VSS sg13g2_decap_4
XDEC2554 VDD VSS sg13g2_decap_4
XDEC2555 VDD VSS sg13g2_decap_4
XDEC2556 VDD VSS sg13g2_decap_4
XDEC2557 VDD VSS sg13g2_decap_4
XDEC2558 VDD VSS sg13g2_decap_4
XDEC2559 VDD VSS sg13g2_decap_4
XDEC2560 VDD VSS sg13g2_decap_4
XDEC2561 VDD VSS sg13g2_decap_4
XDEC2562 VDD VSS sg13g2_decap_4
XDEC2563 VDD VSS sg13g2_decap_4
XDEC2564 VDD VSS sg13g2_decap_4
XDEC2565 VDD VSS sg13g2_decap_4
XDEC2566 VDD VSS sg13g2_decap_4
XDEC2567 VDD VSS sg13g2_decap_4
XDEC2568 VDD VSS sg13g2_decap_4
XDEC2569 VDD VSS sg13g2_decap_4
XDEC2570 VDD VSS sg13g2_decap_4
XDEC2571 VDD VSS sg13g2_decap_4
XDEC2572 VDD VSS sg13g2_decap_4
XDEC2573 VDD VSS sg13g2_decap_4
XDEC2574 VDD VSS sg13g2_decap_4
XDEC2575 VDD VSS sg13g2_decap_4
XDEC2576 VDD VSS sg13g2_decap_4
XDEC2577 VDD VSS sg13g2_decap_4
XDEC2578 VDD VSS sg13g2_decap_4
XDEC2579 VDD VSS sg13g2_decap_4
XDEC2580 VDD VSS sg13g2_decap_4
XDEC2581 VDD VSS sg13g2_decap_4
XDEC2582 VDD VSS sg13g2_decap_4
XDEC2583 VDD VSS sg13g2_decap_4
XDEC2584 VDD VSS sg13g2_decap_4
XDEC2585 VDD VSS sg13g2_decap_4
XDEC2586 VDD VSS sg13g2_decap_4
XDEC2587 VDD VSS sg13g2_decap_4
XDEC2588 VDD VSS sg13g2_decap_4
XDEC2589 VDD VSS sg13g2_decap_4
XDEC2590 VDD VSS sg13g2_decap_4
XDEC2591 VDD VSS sg13g2_decap_4
XDEC2592 VDD VSS sg13g2_decap_4
XDEC2593 VDD VSS sg13g2_decap_4
XDEC2594 VDD VSS sg13g2_decap_4
XDEC2595 VDD VSS sg13g2_decap_4
XDEC2596 VDD VSS sg13g2_decap_4
XDEC2597 VDD VSS sg13g2_decap_4
XDEC2598 VDD VSS sg13g2_decap_4
XDEC2599 VDD VSS sg13g2_decap_4
XDEC2600 VDD VSS sg13g2_decap_4
XDEC2601 VDD VSS sg13g2_decap_4
XDEC2602 VDD VSS sg13g2_decap_4
XDEC2603 VDD VSS sg13g2_decap_4
XDEC2604 VDD VSS sg13g2_decap_4
XDEC2605 VDD VSS sg13g2_decap_4
XDEC2606 VDD VSS sg13g2_decap_4
XDEC2607 VDD VSS sg13g2_decap_4
XDEC2608 VDD VSS sg13g2_decap_4
XDEC2609 VDD VSS sg13g2_decap_4
XDEC2610 VDD VSS sg13g2_decap_4
XDEC2611 VDD VSS sg13g2_decap_4
XDEC2612 VDD VSS sg13g2_decap_4
XDEC2613 VDD VSS sg13g2_decap_4
XDEC2614 VDD VSS sg13g2_decap_4
XDEC2615 VDD VSS sg13g2_decap_4
XDEC2616 VDD VSS sg13g2_decap_4
XDEC2617 VDD VSS sg13g2_decap_4
XDEC2618 VDD VSS sg13g2_decap_4
XDEC2619 VDD VSS sg13g2_decap_4
XDEC2620 VDD VSS sg13g2_decap_4
XDEC2621 VDD VSS sg13g2_decap_4
XDEC2622 VDD VSS sg13g2_decap_4
XDEC2623 VDD VSS sg13g2_decap_4
XDEC2624 VDD VSS sg13g2_decap_4
XDEC2625 VDD VSS sg13g2_decap_4
XDEC2626 VDD VSS sg13g2_decap_4
XDEC2627 VDD VSS sg13g2_decap_4
XDEC2628 VDD VSS sg13g2_decap_4
XDEC2629 VDD VSS sg13g2_decap_4
XDEC2630 VDD VSS sg13g2_decap_4
XDEC2631 VDD VSS sg13g2_decap_4
XDEC2632 VDD VSS sg13g2_decap_4
XDEC2633 VDD VSS sg13g2_decap_4
XDEC2634 VDD VSS sg13g2_decap_4
XDEC2635 VDD VSS sg13g2_decap_4
XDEC2636 VDD VSS sg13g2_decap_4
XDEC2637 VDD VSS sg13g2_decap_4
XDEC2638 VDD VSS sg13g2_decap_4
XDEC2639 VDD VSS sg13g2_decap_4
XDEC2640 VDD VSS sg13g2_decap_4
XDEC2641 VDD VSS sg13g2_decap_4
XDEC2642 VDD VSS sg13g2_decap_4
XDEC2643 VDD VSS sg13g2_decap_4
XDEC2644 VDD VSS sg13g2_decap_4
XDEC2645 VDD VSS sg13g2_decap_4
XDEC2646 VDD VSS sg13g2_decap_4
XDEC2647 VDD VSS sg13g2_decap_4
XDEC2648 VDD VSS sg13g2_decap_4
XDEC2649 VDD VSS sg13g2_decap_4
XDEC2650 VDD VSS sg13g2_decap_4
XDEC2651 VDD VSS sg13g2_decap_4
XDEC2652 VDD VSS sg13g2_decap_4
XDEC2653 VDD VSS sg13g2_decap_4
XDEC2654 VDD VSS sg13g2_decap_4
XDEC2655 VDD VSS sg13g2_decap_4
XDEC2656 VDD VSS sg13g2_decap_4
XDEC2657 VDD VSS sg13g2_decap_4
XDEC2658 VDD VSS sg13g2_decap_4
XDEC2659 VDD VSS sg13g2_decap_4
XDEC2660 VDD VSS sg13g2_decap_4
XDEC2661 VDD VSS sg13g2_decap_4
XDEC2662 VDD VSS sg13g2_decap_4
XDEC2663 VDD VSS sg13g2_decap_4
XDEC2664 VDD VSS sg13g2_decap_4
XDEC2665 VDD VSS sg13g2_decap_4
XDEC2666 VDD VSS sg13g2_decap_4
XDEC2667 VDD VSS sg13g2_decap_4
XDEC2668 VDD VSS sg13g2_decap_4
XDEC2669 VDD VSS sg13g2_decap_4
XDEC2670 VDD VSS sg13g2_decap_4
XDEC2671 VDD VSS sg13g2_decap_4
XDEC2672 VDD VSS sg13g2_decap_4
XDEC2673 VDD VSS sg13g2_decap_4
XDEC2674 VDD VSS sg13g2_decap_4
XDEC2675 VDD VSS sg13g2_decap_4
XDEC2676 VDD VSS sg13g2_decap_4
XDEC2677 VDD VSS sg13g2_decap_4
XDEC2678 VDD VSS sg13g2_decap_4
XDEC2679 VDD VSS sg13g2_decap_4
XDEC2680 VDD VSS sg13g2_decap_4
XDEC2681 VDD VSS sg13g2_decap_4
XDEC2682 VDD VSS sg13g2_decap_4
XDEC2683 VDD VSS sg13g2_decap_4
XDEC2684 VDD VSS sg13g2_decap_4
XDEC2685 VDD VSS sg13g2_decap_4
XDEC2686 VDD VSS sg13g2_decap_4
XDEC2687 VDD VSS sg13g2_decap_4
XDEC2688 VDD VSS sg13g2_decap_4
XDEC2689 VDD VSS sg13g2_decap_4
XDEC2690 VDD VSS sg13g2_decap_4
XDEC2691 VDD VSS sg13g2_decap_4
XDEC2692 VDD VSS sg13g2_decap_4
XDEC2693 VDD VSS sg13g2_decap_4
XDEC2694 VDD VSS sg13g2_decap_4
XDEC2695 VDD VSS sg13g2_decap_4
XDEC2696 VDD VSS sg13g2_decap_4
XDEC2697 VDD VSS sg13g2_decap_4
XDEC2698 VDD VSS sg13g2_decap_4
XDEC2699 VDD VSS sg13g2_decap_4
XDEC2700 VDD VSS sg13g2_decap_4
XDEC2701 VDD VSS sg13g2_decap_4
XDEC2702 VDD VSS sg13g2_decap_4
XDEC2703 VDD VSS sg13g2_decap_4
XDEC2704 VDD VSS sg13g2_decap_4
XDEC2705 VDD VSS sg13g2_decap_4
XDEC2706 VDD VSS sg13g2_decap_4
XDEC2707 VDD VSS sg13g2_decap_4
XDEC2708 VDD VSS sg13g2_decap_4
XDEC2709 VDD VSS sg13g2_decap_4
XDEC2710 VDD VSS sg13g2_decap_4
XDEC2711 VDD VSS sg13g2_decap_4
XDEC2712 VDD VSS sg13g2_decap_4
XDEC2713 VDD VSS sg13g2_decap_4
XDEC2714 VDD VSS sg13g2_decap_4
XDEC2715 VDD VSS sg13g2_decap_4
XDEC2716 VDD VSS sg13g2_decap_4
XDEC2717 VDD VSS sg13g2_decap_4
XDEC2718 VDD VSS sg13g2_decap_4
XDEC2719 VDD VSS sg13g2_decap_4
XDEC2720 VDD VSS sg13g2_decap_4
XDEC2721 VDD VSS sg13g2_decap_4
XDEC2722 VDD VSS sg13g2_decap_4
XDEC2723 VDD VSS sg13g2_decap_4
XDEC2724 VDD VSS sg13g2_decap_4
XDEC2725 VDD VSS sg13g2_decap_4
XDEC2726 VDD VSS sg13g2_decap_4
XDEC2727 VDD VSS sg13g2_decap_4
XDEC2728 VDD VSS sg13g2_decap_4
XDEC2729 VDD VSS sg13g2_decap_4
XDEC2730 VDD VSS sg13g2_decap_4
XDEC2731 VDD VSS sg13g2_decap_4
XDEC2732 VDD VSS sg13g2_decap_4
XDEC2733 VDD VSS sg13g2_decap_4
XDEC2734 VDD VSS sg13g2_decap_4
XDEC2735 VDD VSS sg13g2_decap_4
XDEC2736 VDD VSS sg13g2_decap_4
XDEC2737 VDD VSS sg13g2_decap_4
XDEC2738 VDD VSS sg13g2_decap_4
XDEC2739 VDD VSS sg13g2_decap_4
XDEC2740 VDD VSS sg13g2_decap_4
XDEC2741 VDD VSS sg13g2_decap_4
XDEC2742 VDD VSS sg13g2_decap_4
XDEC2743 VDD VSS sg13g2_decap_4
XDEC2744 VDD VSS sg13g2_decap_4
XDEC2745 VDD VSS sg13g2_decap_4
XDEC2746 VDD VSS sg13g2_decap_4
XDEC2747 VDD VSS sg13g2_decap_4
XDEC2748 VDD VSS sg13g2_decap_4
XDEC2749 VDD VSS sg13g2_decap_4
XDEC2750 VDD VSS sg13g2_decap_4
XDEC2751 VDD VSS sg13g2_decap_4
XDEC2752 VDD VSS sg13g2_decap_4
XDEC2753 VDD VSS sg13g2_decap_4
XDEC2754 VDD VSS sg13g2_decap_4
XDEC2755 VDD VSS sg13g2_decap_4
XDEC2756 VDD VSS sg13g2_decap_4
XDEC2757 VDD VSS sg13g2_decap_4
XDEC2758 VDD VSS sg13g2_decap_4
XDEC2759 VDD VSS sg13g2_decap_4
XDEC2760 VDD VSS sg13g2_decap_4
XDEC2761 VDD VSS sg13g2_decap_4
XDEC2762 VDD VSS sg13g2_decap_4
XDEC2763 VDD VSS sg13g2_decap_4
XDEC2764 VDD VSS sg13g2_decap_4
XDEC2765 VDD VSS sg13g2_decap_4
XDEC2766 VDD VSS sg13g2_decap_4
XDEC2767 VDD VSS sg13g2_decap_4
XDEC2768 VDD VSS sg13g2_decap_4
XDEC2769 VDD VSS sg13g2_decap_4
XDEC2770 VDD VSS sg13g2_decap_4
XDEC2771 VDD VSS sg13g2_decap_4
XDEC2772 VDD VSS sg13g2_decap_4
XDEC2773 VDD VSS sg13g2_decap_4
XDEC2774 VDD VSS sg13g2_decap_4
XDEC2775 VDD VSS sg13g2_decap_4
XDEC2776 VDD VSS sg13g2_decap_4
XDEC2777 VDD VSS sg13g2_decap_4
XDEC2778 VDD VSS sg13g2_decap_4
XDEC2779 VDD VSS sg13g2_decap_4
XDEC2780 VDD VSS sg13g2_decap_4
XDEC2781 VDD VSS sg13g2_decap_4
XDEC2782 VDD VSS sg13g2_decap_4
XDEC2783 VDD VSS sg13g2_decap_4
XDEC2784 VDD VSS sg13g2_decap_4
XDEC2785 VDD VSS sg13g2_decap_4
XDEC2786 VDD VSS sg13g2_decap_4
XDEC2787 VDD VSS sg13g2_decap_4
XDEC2788 VDD VSS sg13g2_decap_4
XDEC2789 VDD VSS sg13g2_decap_4
XDEC2790 VDD VSS sg13g2_decap_4
XDEC2791 VDD VSS sg13g2_decap_4
XDEC2792 VDD VSS sg13g2_decap_4
XDEC2793 VDD VSS sg13g2_decap_4
XDEC2794 VDD VSS sg13g2_decap_4
XDEC2795 VDD VSS sg13g2_decap_4
XDEC2796 VDD VSS sg13g2_decap_4
XDEC2797 VDD VSS sg13g2_decap_4
XDEC2798 VDD VSS sg13g2_decap_4
XDEC2799 VDD VSS sg13g2_decap_4
XDEC2800 VDD VSS sg13g2_decap_4
XDEC2801 VDD VSS sg13g2_decap_4
XDEC2802 VDD VSS sg13g2_decap_4
XDEC2803 VDD VSS sg13g2_decap_4
XDEC2804 VDD VSS sg13g2_decap_4
XDEC2805 VDD VSS sg13g2_decap_4
XDEC2806 VDD VSS sg13g2_decap_4
XDEC2807 VDD VSS sg13g2_decap_4
XDEC2808 VDD VSS sg13g2_decap_4
XDEC2809 VDD VSS sg13g2_decap_4
XDEC2810 VDD VSS sg13g2_decap_4
XDEC2811 VDD VSS sg13g2_decap_4
XDEC2812 VDD VSS sg13g2_decap_4
XDEC2813 VDD VSS sg13g2_decap_4
XDEC2814 VDD VSS sg13g2_decap_4
XDEC2815 VDD VSS sg13g2_decap_4
XDEC2816 VDD VSS sg13g2_decap_4
XDEC2817 VDD VSS sg13g2_decap_4
XDEC2818 VDD VSS sg13g2_decap_4
XDEC2819 VDD VSS sg13g2_decap_4
XDEC2820 VDD VSS sg13g2_decap_4
XDEC2821 VDD VSS sg13g2_decap_4
XDEC2822 VDD VSS sg13g2_decap_4
XDEC2823 VDD VSS sg13g2_decap_4
XDEC2824 VDD VSS sg13g2_decap_4
XDEC2825 VDD VSS sg13g2_decap_4
XDEC2826 VDD VSS sg13g2_decap_4
XDEC2827 VDD VSS sg13g2_decap_4
XDEC2828 VDD VSS sg13g2_decap_4
XDEC2829 VDD VSS sg13g2_decap_4
XDEC2830 VDD VSS sg13g2_decap_4
XDEC2831 VDD VSS sg13g2_decap_4
XDEC2832 VDD VSS sg13g2_decap_4
XDEC2833 VDD VSS sg13g2_decap_4
XDEC2834 VDD VSS sg13g2_decap_4
XDEC2835 VDD VSS sg13g2_decap_4
XDEC2836 VDD VSS sg13g2_decap_4
XDEC2837 VDD VSS sg13g2_decap_4
XDEC2838 VDD VSS sg13g2_decap_4
XDEC2839 VDD VSS sg13g2_decap_4
XDEC2840 VDD VSS sg13g2_decap_4
XDEC2841 VDD VSS sg13g2_decap_4
XDEC2842 VDD VSS sg13g2_decap_4
XDEC2843 VDD VSS sg13g2_decap_4
XDEC2844 VDD VSS sg13g2_decap_4
XDEC2845 VDD VSS sg13g2_decap_4
XDEC2846 VDD VSS sg13g2_decap_4

.ENDS digital_block_top
